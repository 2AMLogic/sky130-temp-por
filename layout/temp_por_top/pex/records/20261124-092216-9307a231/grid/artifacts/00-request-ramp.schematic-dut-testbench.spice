* klt pex block-level testbench (issue #454 step 3): supply-ramp release measurement.
* Stimulus = sim/supply-ramp-top tb_temp_por_ramp.sch: physical 0 V start,
* V(VDD) = min(vf, rate*t), rate 10000 V/s (the sim/iq-top rate), held to tstop 30 ms.
* Measurements (.meas cards come from request-ramp.json) reference top-level
* nodes only (VDD, RESETn): the extracted leg is flat, so DUT-internal nets
* (POR_RAW, IBIAS, ...) do not exist there.
* Release definition = sim/supply-ramp-top grading: first rising V_IH = 0.8*vf
* crossing of RESETn (Schmitt output, starts LOW). vf = 3.30 V -> V_IH = 2.64 V.
.param rate=10000
* ng_nomodcheck: same setting as sim/spiceinit; carried in the netlist because the
* fleet runner ignores options.ngspice_init (see sim/supply-ramp-top experiment.json)
.control
set ng_nomodcheck
.endc
** sch_path: sim/supply-ramp-top/testbench/tb_temp_por_ramp.sch (stimulus source)
**.subckt tb_temp_por_ramp
VSET VSETN 0 3.3
BVDD VDD 0 V = min(v(VSETN), {rate}*time)
XDUT VDD 0 PTAT CTAT RESETn temp_por_top
**** begin user architecture code

.save v(vdd) v(resetn) i(bvdd) v(ptat) v(ctat)
.options method=gear trtol=50

**** end user architecture code
**.ends
.include "/home/ubuntu/GitHub/sky130-temp-por/.loom/worktrees/issue-501/layout/temp_por_top/pex/records/20261124-092216-9307a231/grid/artifacts/schematic-dut.flat.spice"
