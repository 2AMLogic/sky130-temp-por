* klt sim -- generated corner deck, do not edit
.lib /opt/pdk/sky130A/libs.tech/combined/sky130.lib.spice sf
.include /var/tmp/eda-job-klt-sim-b045bed9e20c/inputs/netlist.cir
.temp -40
.meas tran t_release_v_ih WHEN v(resetn)=2.64 RISE=1
.meas tran vdd_at_release FIND v(vdd) WHEN v(resetn)=2.64 RISE=1
.control
save all
alter vset=2.97
tran 1u 0.03 0 1e-05
quit
.endc
.end
