* klt sim -- generated corner deck, do not edit
.lib /opt/pdk/sky130A/libs.tech/combined/sky130.lib.spice tt
.include /var/tmp/eda-job-klt-sim-4262093e8dde/inputs/netlist.cir
.temp 125
.meas tran iq_por_settled AVG i(bvdd) FROM=0.025 TO=0.03
.control
save all
alter vset=3.63
tran 1u 0.03 0 1e-05
quit
.endc
.end
