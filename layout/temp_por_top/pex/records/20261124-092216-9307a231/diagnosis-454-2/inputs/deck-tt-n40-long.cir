.lib ~/.ciel/sky130A/libs.tech/combined/sky130.lib.spice tt
.include ./tb.spice
.include <repo>/layout/temp_por_top/pex/records/20261124-092216-9307a231/grid/temp_por_top.pex.spice
.temp -40
.meas tran t_release_v_ih WHEN v(resetn)=2.64 RISE=1
.control
set ng_nomodcheck
save all
alter vset=3.3
tran 1u 0.3 0 1e-05
meas tran vdd30 FIND v(vdd) AT=0.03
meas tran ptat30 FIND v(ptat) AT=0.03
meas tran ctat30 FIND v(ctat) AT=0.03
meas tran r_end FIND v(resetn) AT=0.3
meas tran r_100m FIND v(resetn) AT=0.1
meas tran r_200m FIND v(resetn) AT=0.2
meas tran ptat_100m FIND v(ptat) AT=0.1
meas tran ptat_200m FIND v(ptat) AT=0.2
meas tran ptatmax MAX v(ptat)
meas tran r_10m FIND v(resetn) AT=0.01
meas tran r_20m FIND v(resetn) AT=0.02
meas tran vmax MAX v(resetn)
quit
.endc
.end
