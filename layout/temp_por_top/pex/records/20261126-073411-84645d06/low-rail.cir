* Schematic sf/2.970V/-40C check using the klt-generated schematic testbench.
.lib sky130.lib.spice sf
.include schematic-testbench.spice
.temp -40
.control
save all
alter vset=2.97
tran 1u 0.03 0 1e-05
meas tran t_release_v_ih WHEN v(resetn)=v(vth) RISE=1
meas tran vdd_at_release FIND v(vdd) WHEN v(resetn)=v(vth) RISE=1
meas tran t_literal WHEN v(resetn)=2.376 RISE=1
meas tran vdd_literal FIND v(vdd) WHEN v(resetn)=2.376 RISE=1
meas tran t_fixed WHEN v(resetn)=2.64 RISE=1
meas tran vdd_fixed FIND v(vdd) WHEN v(resetn)=2.64 RISE=1
meas tran resetn_max MAX v(resetn)
set wr_singlescale
set wr_vecnames
set numdgt=15
wrdata waveform.txt v(resetn) v(vdd) v(vth)
quit
.endc
.end
