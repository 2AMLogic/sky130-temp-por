* Reference netlist for bias_core_passives LVS -- GENERATED by layout/bin/compose-cell.py
* Source: layout/bias_core_passives/reference.spice .subckt bias_core_passives
* Only unit spellings (and any substituted subckt parameter)
* differ from the source -- see compose-cell.py's docstring.
.subckt bias_core_passives NBTOP NB EC VREF ER NZ N2 PG VDD NOKX VSS
XRT NBTOP NB VSS sky130_fd_pr__res_xhigh_po W=2u L=17.5u mult=1 m=1
XR1 NB EC VSS sky130_fd_pr__res_xhigh_po W=2u L=350.0u mult=1 m=1
XR2 VREF ER VSS sky130_fd_pr__res_xhigh_po W=2u L=4104.0u mult=1 m=1
XCC PG NZ sky130_fd_pr__cap_mim_m3_1 W=20u L=20u MF=1 m=1
XRZ NZ N2 VSS sky130_fd_pr__res_xhigh_po W=2u L=1016.0u mult=1 m=1
XCOK VDD NOKX sky130_fd_pr__cap_mim_m3_1 W=6u L=6u MF=1 m=1
.ends
