* extracted by klt extract --deck sky130

* cell bias_core_passives
* pin N2
* pin NB
* pin NZ
* pin PG
* pin ec
* pin er
* pin nbtop
* pin nokx
* pin vdd
* pin vref
* pin vsubs
.SUBCKT bias_core_passives N2 NB NZ PG ec er nbtop nokx vdd vref vsubs
* device instance $1 r0 *1 1739.09,10.5 sky130_fd_pr__model__cap_mim
C$1 NZ PG 8.152e-13
* device instance $2 r0 *1 5864.37,3.5 sky130_fd_pr__model__cap_mim
C$2 vdd nokx 7.656e-14
* device instance $3 r0 *1 175.39,1 res_xhigh_po
X$3 nbtop NB vsubs res_xhigh_po r=350000 L=350U W=2U
* device instance $4 r0 *1 529.67,1 res_xhigh_po
X$4 NB ec vsubs res_xhigh_po r=350000 L=350U W=2U
* device instance $5 r0 *1 1216.95,1 res_xhigh_po
X$5 N2 NZ vsubs res_xhigh_po r=1016000 L=1016U W=2U
* device instance $6 r0 *1 3805.23,1 res_xhigh_po
X$6 vref er vsubs res_xhigh_po r=4104000 L=4104U W=2U
.ENDS bias_core_passives
