* extracted by klt extract --deck sky130

* cell bias_core_passives
* pin ec
* pin er
* pin n2
* pin nb
* pin nbtop
* pin nokx
* pin nz
* pin pg
* pin vdd
* pin vref
* pin vsubs
.SUBCKT bias_core_passives ec er n2 nb nbtop nokx nz pg vdd vref vsubs
* device instance $1 r0 *1 1739.09,10.5 sky130_fd_pr__model__cap_mim
C$1 nz pg 8.152e-13
* device instance $2 r0 *1 5864.37,3.5 sky130_fd_pr__model__cap_mim
C$2 vdd nokx 7.656e-14
* device instance $3 r0 *1 175.39,1 res_xhigh_po
X$3 nbtop nb vsubs res_xhigh_po r=350000 L=350U W=2U
* device instance $4 r0 *1 529.67,1 res_xhigh_po
X$4 nb ec vsubs res_xhigh_po r=350000 L=350U W=2U
* device instance $5 r0 *1 1216.95,1 res_xhigh_po
X$5 n2 nz vsubs res_xhigh_po r=1016000 L=1016U W=2U
* device instance $6 r0 *1 3805.23,1 res_xhigh_po
X$6 vref er vsubs res_xhigh_po r=4104000 L=4104U W=2U
.ENDS bias_core_passives
