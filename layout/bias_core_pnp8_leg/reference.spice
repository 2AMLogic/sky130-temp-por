* bias_core_pnp8_leg -- LVS reference for layout/bias_core_pnp8_leg/cell.json
*
* NOT an xschem export. Hand-extracted, verbatim (device cards unmodified
* except for the wrapping .subckt/.ends and the two shared port names), from
* design/netlist/bias_core.spice's own XQ8A..XQ8H device cards -- the
* "8:1 PNP emitter-count ratio" leg design/bias_core.md's sizing section
* describes. Every device card below must stay byte-for-byte identical to
* the corresponding line in design/netlist/bias_core.spice; if
* design/bias_core.sch's XQ8* group ever changes, this file needs the same
* change or layout/bin/compose-cell.py's LVS step (comparing against this
* file) stops meaning anything.
*
* In the full bias_core netlist every one of these 8 calls is literally
* "VSS VSS EC" (collector=VSS, base=VSS, emitter=EC) -- i.e. collector and
* base both land on bias_core's own VSS rail and never need a distinct net
* of their own here, so this reference exposes only two ports.
.subckt bias_core_pnp8_leg EC VSS
XQ8A VSS VSS EC sky130_fd_pr__pnp_05v5_W3p40L3p40 m=1 mult=1
XQ8B VSS VSS EC sky130_fd_pr__pnp_05v5_W3p40L3p40 m=1 mult=1
XQ8C VSS VSS EC sky130_fd_pr__pnp_05v5_W3p40L3p40 m=1 mult=1
XQ8D VSS VSS EC sky130_fd_pr__pnp_05v5_W3p40L3p40 m=1 mult=1
XQ8E VSS VSS EC sky130_fd_pr__pnp_05v5_W3p40L3p40 m=1 mult=1
XQ8F VSS VSS EC sky130_fd_pr__pnp_05v5_W3p40L3p40 m=1 mult=1
XQ8G VSS VSS EC sky130_fd_pr__pnp_05v5_W3p40L3p40 m=1 mult=1
XQ8H VSS VSS EC sky130_fd_pr__pnp_05v5_W3p40L3p40 m=1 mult=1
.ends
