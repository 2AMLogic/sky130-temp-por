* Reference netlist for bias_core_pnp8_leg LVS -- GENERATED by layout/bin/compose-cell.py
* Source: layout/bias_core_pnp8_leg/reference.spice .subckt bias_core_pnp8_leg
* Only unit spellings (and any substituted subckt parameter)
* differ from the source -- see compose-cell.py's docstring.
.subckt bias_core_pnp8_leg EC VSS
XQ8A VSS VSS EC sky130_fd_pr__pnp_05v5_W3p40L3p40 m=1 mult=1
XQ8B VSS VSS EC sky130_fd_pr__pnp_05v5_W3p40L3p40 m=1 mult=1
XQ8C VSS VSS EC sky130_fd_pr__pnp_05v5_W3p40L3p40 m=1 mult=1
XQ8D VSS VSS EC sky130_fd_pr__pnp_05v5_W3p40L3p40 m=1 mult=1
XQ8E VSS VSS EC sky130_fd_pr__pnp_05v5_W3p40L3p40 m=1 mult=1
XQ8F VSS VSS EC sky130_fd_pr__pnp_05v5_W3p40L3p40 m=1 mult=1
XQ8G VSS VSS EC sky130_fd_pr__pnp_05v5_W3p40L3p40 m=1 mult=1
XQ8H VSS VSS EC sky130_fd_pr__pnp_05v5_W3p40L3p40 m=1 mult=1
.ends
