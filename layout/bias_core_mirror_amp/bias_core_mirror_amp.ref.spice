* Reference netlist for bias_core_mirror_amp LVS -- GENERATED by layout/bin/compose-cell.py
* Source: layout/bias_core_mirror_amp/reference.spice .subckt bias_core_mirror_amp
* Only unit spellings (and any substituted subckt parameter)
* differ from the source -- see compose-cell.py's docstring.
.subckt bias_core_mirror_amp VDD VSS PG NA NBTOP VREF NBG PB NT N1 N2 IBIAS NB
XMP1 NA PG VDD VDD sky130_fd_pr__pfet_g5v0d10v5 L=4u W=8u nf=1 ad=2.32 as=2.32 pd=16.58 ps=16.58 nrd=0.03625 nrs=0.03625 sa=0 sb=0
+ sd=0 mult=1 m=1
XMP2 NBTOP PG VDD VDD sky130_fd_pr__pfet_g5v0d10v5 L=4u W=8u nf=1 ad=2.32 as=2.32 pd=16.58 ps=16.58 nrd=0.03625 nrs=0.03625 sa=0
+ sb=0 sd=0 mult=1 m=1
XMP3 VREF PG VDD VDD sky130_fd_pr__pfet_g5v0d10v5 L=4u W=8u nf=1 ad=2.32 as=2.32 pd=16.58 ps=16.58 nrd=0.03625 nrs=0.03625 sa=0 sb=0
+ sd=0 mult=1 m=1
XMPBN NBG PG VDD VDD sky130_fd_pr__pfet_g5v0d10v5 L=4u W=2u nf=1 ad=0.58 as=0.58 pd=4.58 ps=4.58 nrd=0.145 nrs=0.145 sa=0 sb=0 sd=0
+ mult=1 m=1
XMBN NBG NBG VSS VSS sky130_fd_pr__nfet_g5v0d10v5 L=4u W=2u nf=1 ad=0.58 as=0.58 pd=4.58 ps=4.58 nrd=0.145 nrs=0.145 sa=0 sb=0 sd=0
+ mult=1 m=1
XMBN2 PB NBG VSS VSS sky130_fd_pr__nfet_g5v0d10v5 L=4u W=2u nf=1 ad=0.58 as=0.58 pd=4.58 ps=4.58 nrd=0.145 nrs=0.145 sa=0 sb=0 sd=0
+ mult=1 m=1
XMBP PB PB VDD VDD sky130_fd_pr__pfet_g5v0d10v5 L=4u W=2u nf=1 ad=0.58 as=0.58 pd=4.58 ps=4.58 nrd=0.145 nrs=0.145 sa=0 sb=0 sd=0
+ mult=1 m=1
XMPIB IBIAS PB VDD VDD sky130_fd_pr__pfet_g5v0d10v5 L=4u W=40u nf=1 ad=11.6 as=11.6 pd=80.58 ps=80.58 nrd=0.00725 nrs=0.00725 sa=0
+ sb=0 sd=0 mult=1 m=1
XMPT NT PB VDD VDD sky130_fd_pr__pfet_g5v0d10v5 L=4u W=2u nf=1 ad=0.58 as=0.58 pd=4.58 ps=4.58 nrd=0.145 nrs=0.145 sa=0 sb=0 sd=0
+ mult=1 m=1
XMI1 N1 NA NT VDD sky130_fd_pr__pfet_g5v0d10v5 L=4u W=16u nf=1 ad=4.64 as=4.64 pd=32.58 ps=32.58 nrd=0.018125 nrs=0.018125 sa=0 sb=0
+ sd=0 mult=1 m=1
XMI2 N2 NB NT VDD sky130_fd_pr__pfet_g5v0d10v5 L=4u W=16u nf=1 ad=4.64 as=4.64 pd=32.58 ps=32.58 nrd=0.018125 nrs=0.018125 sa=0 sb=0
+ sd=0 mult=1 m=1
XML1 N1 N1 VSS VSS sky130_fd_pr__nfet_g5v0d10v5 L=8u W=4u nf=1 ad=1.16 as=1.16 pd=8.58 ps=8.58 nrd=0.0725 nrs=0.0725 sa=0 sb=0 sd=0
+ mult=1 m=1
XML2 N2 N1 VSS VSS sky130_fd_pr__nfet_g5v0d10v5 L=8u W=4u nf=1 ad=1.16 as=1.16 pd=8.58 ps=8.58 nrd=0.0725 nrs=0.0725 sa=0 sb=0 sd=0
+ mult=1 m=1
XMS2N PG N2 VSS VSS sky130_fd_pr__nfet_g5v0d10v5 L=8u W=8u nf=1 ad=2.32 as=2.32 pd=16.58 ps=16.58 nrd=0.03625 nrs=0.03625 sa=0 sb=0
+ sd=0 mult=1 m=1
XMS2P PG PB VDD VDD sky130_fd_pr__pfet_g5v0d10v5 L=4u W=2u nf=1 ad=0.58 as=0.58 pd=4.58 ps=4.58 nrd=0.145 nrs=0.145 sa=0 sb=0 sd=0
+ mult=1 m=1
.ends bias_core_mirror_amp
