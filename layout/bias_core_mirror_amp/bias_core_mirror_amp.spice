* extracted by klt extract --deck sky130

* cell bias_core_mirror_amp
* pin N1
* pin N2
* pin NA
* pin NB
* pin NBG
* pin NT
* pin PB
* pin PG
* pin ibias
* pin nbtop
* pin vdd
* pin vref
* pin vss
.SUBCKT bias_core_mirror_amp N1 N2 NA NB NBG NT PB PG ibias nbtop vdd vref vss
* device instance $1 r0 *1 26.42,1 nfet
M$1 NBG NBG vss vss nfet L=4U W=2U AS=0.84P AD=0.84P PS=4.84U PD=4.84U
* device instance $2 r0 *1 33.42,1 nfet
M$2 PB NBG vss vss nfet L=4U W=2U AS=0.84P AD=0.84P PS=4.84U PD=4.84U
* device instance $3 r0 *1 72.42,2 nfet
M$3 N1 N1 vss vss nfet L=8U W=4U AS=1.68P AD=1.68P PS=8.84U PD=8.84U
* device instance $4 r0 *1 83.42,2 nfet
M$4 N2 N1 vss vss nfet L=8U W=4U AS=1.68P AD=1.68P PS=8.84U PD=8.84U
* device instance $5 r0 *1 42.42,4 nfet
M$5 PG N2 vss vss nfet L=8U W=8U AS=3.36P AD=3.36P PS=16.84U PD=16.84U
* device instance $6 r0 *1 29.42,23.97 pfet
M$6 NBG PG vdd vdd pfet L=4U W=2U AS=0.84P AD=0.84P PS=4.84U PD=4.84U
* device instance $7 r0 *1 38.42,23.97 pfet
M$7 PG PB vdd vdd pfet L=4U W=2U AS=0.84P AD=0.84P PS=4.84U PD=4.84U
* device instance $8 r0 *1 47.42,23.97 pfet
M$8 PB PB vdd vdd pfet L=4U W=2U AS=0.84P AD=0.84P PS=4.84U PD=4.84U
* device instance $9 r0 *1 65.42,23.97 pfet
M$9 NT PB vdd vdd pfet L=4U W=2U AS=0.84P AD=0.84P PS=4.84U PD=4.84U
* device instance $10 r0 *1 2.42,26.97 pfet
M$10 nbtop PG vdd vdd pfet L=4U W=8U AS=3.36P AD=3.36P PS=16.84U PD=16.84U
* device instance $11 r0 *1 11.42,26.97 pfet
M$11 vref PG vdd vdd pfet L=4U W=8U AS=3.36P AD=3.36P PS=16.84U PD=16.84U
* device instance $12 r0 *1 20.42,26.97 pfet
M$12 NA PG vdd vdd pfet L=4U W=8U AS=3.36P AD=3.36P PS=16.84U PD=16.84U
* device instance $13 r0 *1 74.42,30.97 pfet
M$13 N1 NA NT vdd pfet L=4U W=16U AS=6.72P AD=6.72P PS=32.84U PD=32.84U
* device instance $14 r0 *1 83.42,30.97 pfet
M$14 N2 NB NT vdd pfet L=4U W=16U AS=6.72P AD=6.72P PS=32.84U PD=32.84U
* device instance $15 r0 *1 56.42,42.97 pfet
M$15 ibias PB vdd vdd pfet L=4U W=40U AS=16.8P AD=16.8P PS=80.84U PD=80.84U
.ENDS bias_core_mirror_amp
