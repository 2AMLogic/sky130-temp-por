* Reference netlist for bias_core_xq1_xqr LVS -- GENERATED by layout/bin/compose-cell.py
* Source: layout/bias_core_xq1_xqr/reference.spice .subckt bias_core_xq1_xqr
* Mechanically rewritten from the source by build_reference -- see
* compose-cell.py's docstring for the exact transformations.
.subckt bias_core_xq1_xqr NA ER VSS
XQ1 VSS VSS NA sky130_fd_pr__pnp_05v5_W3p40L3p40 m=1 mult=1
XQR VSS VSS ER sky130_fd_pr__pnp_05v5_W3p40L3p40 m=1 mult=1
.ends
