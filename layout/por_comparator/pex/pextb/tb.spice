* klt pex spot-check testbench (issue #124): same stimulus as sim/por-comparator-thresholds ideal-bias @100 V/s,
* DUT .included so klt pex can re-point it at the extracted netlist.
* por-comparator-thresholds: generated by sim/por-comparator-thresholds/run_thresholds_campaign.py -- do not edit
* sweep rate (V/s, up and down): 100
.param rate=100
* ng_nomodcheck: same setting as sim/spiceinit; carried in the netlist because the
* fleet runner ignores options.ngspice_init (see experiment.json ngspice_note)
.control
set ng_nomodcheck
.endc
** sch_path: sim/por-comparator-thresholds/testbench/tb_por_comparator_thresholds.sch
**.subckt tb_por_comparator_thresholds
VSET VSETN 0 3.63
BVDD VDD 0 V = min(v(VSETN), min({rate}*time, max(0, 2*v(VSETN) - {rate}*time)))
XDUT VDD 0 IBIAS VREF BIAS_OK POR_RAW por_comparator
IIB 0 IBIAS 1u
BVREF VREF 0 V = min(1.25, v(VDD))
BBOK BIAS_OK 0 V = v(VDD)
**** begin user architecture code

.save v(vdd) v(por_raw) v(vref) v(ibias) v(bias_ok) i(bvdd)
.save v(xdut.sns) v(xdut.snsb) v(xdut.n1) v(xdut.cmpo)
.options method=gear trtol=50

**** end user architecture code
**.ends
.include ../../../../design/netlist/por_comparator.spice
