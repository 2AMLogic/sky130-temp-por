* Reference netlist for por_comparator LVS -- GENERATED by layout/bin/compose-cell.py
* Source: design/netlist/por_comparator.spice .subckt por_comparator
* Only unit spellings (and any substituted subckt parameter)
* differ from the source -- see compose-cell.py's docstring.
.subckt por_comparator VDD VSS IBIAS VREF BIAS_OK POR_RAW
*.PININFO VDD:B VSS:B IBIAS:I VREF:I BIAS_OK:I POR_RAW:O
XMENP BIAS_OKB BIAS_OK VDD VDD sky130_fd_pr__pfet_g5v0d10v5 L=0.5u W=2u nf=1 ad=0.58 as=0.58 pd=4.58 ps=4.58 nrd=0.145 nrs=0.145
+ sa=0 sb=0 sd=0 mult=1 m=1
XMENN BIAS_OKB BIAS_OK VSS VSS sky130_fd_pr__nfet_g5v0d10v5 L=0.5u W=1u nf=1 ad=0.29 as=0.29 pd=2.58 ps=2.58 nrd=0.29 nrs=0.29 sa=0
+ sb=0 sd=0 mult=1 m=1
XMBD IBIAS NBG VSS VSS sky130_fd_pr__nfet_g5v0d10v5 L=2u W=2u nf=1 ad=0.58 as=0.58 pd=4.58 ps=4.58 nrd=0.145 nrs=0.145 sa=0 sb=0
+ sd=0 mult=1 m=1
XMPASS IBIAS BIAS_OK NBG VSS sky130_fd_pr__nfet_g5v0d10v5 L=0.5u W=2u nf=1 ad=0.58 as=0.58 pd=4.58 ps=4.58 nrd=0.145 nrs=0.145 sa=0
+ sb=0 sd=0 mult=1 m=1
XMDNB NBG BIAS_OKB VSS VSS sky130_fd_pr__nfet_g5v0d10v5 L=0.5u W=2u nf=1 ad=0.58 as=0.58 pd=4.58 ps=4.58 nrd=0.145 nrs=0.145 sa=0
+ sb=0 sd=0 mult=1 m=1
XMDIB IBIAS BIAS_OKB VSS VSS sky130_fd_pr__nfet_g5v0d10v5 L=1u W=1u nf=1 ad=0.29 as=0.29 pd=2.58 ps=2.58 nrd=0.29 nrs=0.29 sa=0 sb=0
+ sd=0 mult=1 m=1
XRTOP SNS VDD VSS sky130_fd_pr__res_xhigh_po W=2u L=7897.44u mult=1 m=1
XRBOT SNSB SNS VSS sky130_fd_pr__res_xhigh_po W=2u L=6769.23u mult=1 m=1
XRHYS VSS SNSB VSS sky130_fd_pr__res_xhigh_po W=2u L=775.0u mult=1 m=1
XMHSW SNSB N1 VSS VSS sky130_fd_pr__nfet_g5v0d10v5 L=0.5u W=10u nf=1 ad=2.9 as=2.9 pd=20.58 ps=20.58 nrd=0.029 nrs=0.029 sa=0 sb=0
+ sd=0 mult=1 m=1
XMTAIL TN NBG VSS VSS sky130_fd_pr__nfet_g5v0d10v5 L=10u W=1u nf=1 ad=0.29 as=0.29 pd=2.58 ps=2.58 nrd=0.29 nrs=0.29 sa=0 sb=0 sd=0
+ mult=1 m=1
XMINA NA SNS TN VSS sky130_fd_pr__nfet_g5v0d10v5 L=1u W=2u nf=1 ad=0.58 as=0.58 pd=4.58 ps=4.58 nrd=0.145 nrs=0.145 sa=0 sb=0 sd=0
+ mult=1 m=1
XMINB CMPO VREF TN VSS sky130_fd_pr__nfet_g5v0d10v5 L=1u W=2u nf=1 ad=0.58 as=0.58 pd=4.58 ps=4.58 nrd=0.145 nrs=0.145 sa=0 sb=0
+ sd=0 mult=1 m=1
XMLA NA NA VDDA VDD sky130_fd_pr__pfet_g5v0d10v5 L=1u W=4u nf=1 ad=1.16 as=1.16 pd=8.58 ps=8.58 nrd=0.0725 nrs=0.0725 sa=0 sb=0 sd=0
+ mult=1 m=1
XMLB CMPO NA VDDA VDD sky130_fd_pr__pfet_g5v0d10v5 L=1u W=4u nf=1 ad=1.16 as=1.16 pd=8.58 ps=8.58 nrd=0.0725 nrs=0.0725 sa=0 sb=0
+ sd=0 mult=1 m=1
XMENSRC VDDA BIAS_OKB VDD VDD sky130_fd_pr__pfet_g5v0d10v5 L=0.5u W=4u nf=1 ad=1.16 as=1.16 pd=8.58 ps=8.58 nrd=0.0725 nrs=0.0725
+ sa=0 sb=0 sd=0 mult=1 m=1
XMDCMPO CMPO BIAS_OKB VSS VSS sky130_fd_pr__nfet_g5v0d10v5 L=1u W=2u nf=1 ad=0.58 as=0.58 pd=4.58 ps=4.58 nrd=0.145 nrs=0.145 sa=0
+ sb=0 sd=0 mult=1 m=1
XMI1P N1 CMPO VDD VDD sky130_fd_pr__pfet_g5v0d10v5 L=0.5u W=2u nf=1 ad=0.58 as=0.58 pd=4.58 ps=4.58 nrd=0.145 nrs=0.145 sa=0 sb=0
+ sd=0 mult=1 m=1
XMI1N N1 CMPO VSS VSS sky130_fd_pr__nfet_g5v0d10v5 L=0.5u W=1u nf=1 ad=0.29 as=0.29 pd=2.58 ps=2.58 nrd=0.29 nrs=0.29 sa=0 sb=0 sd=0
+ mult=1 m=1
XMI2P POR_RAW N1 VDD VDD sky130_fd_pr__pfet_g5v0d10v5 L=0.5u W=2u nf=1 ad=0.58 as=0.58 pd=4.58 ps=4.58 nrd=0.145 nrs=0.145 sa=0 sb=0
+ sd=0 mult=1 m=1
XMI2N POR_RAW N1 VSS VSS sky130_fd_pr__nfet_g5v0d10v5 L=0.5u W=1u nf=1 ad=0.29 as=0.29 pd=2.58 ps=2.58 nrd=0.29 nrs=0.29 sa=0 sb=0
+ sd=0 mult=1 m=1
.ends
