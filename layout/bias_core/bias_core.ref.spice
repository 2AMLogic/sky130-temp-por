* Reference netlist for bias_core LVS -- GENERATED by layout/bin/compose-cell.py
* Source: design/netlist/bias_core.spice .subckt bias_core
* Only unit spellings (and any substituted subckt parameter)
* differ from the source -- see compose-cell.py's docstring.
.subckt bias_core VDD VSS IBIAS VREF BIAS_OK
*.PININFO VDD:B VSS:B IBIAS:O VREF:O BIAS_OK:O
XMP1 NA PG VDD VDD sky130_fd_pr__pfet_g5v0d10v5 L=4u W=8u nf=1 ad=2.32 as=2.32 pd=16.58 ps=16.58 nrd=0.03625 nrs=0.03625 sa=0 sb=0
+ sd=0 mult=1 m=1
XMP2 NBTOP PG VDD VDD sky130_fd_pr__pfet_g5v0d10v5 L=4u W=8u nf=1 ad=2.32 as=2.32 pd=16.58 ps=16.58 nrd=0.03625 nrs=0.03625 sa=0
+ sb=0 sd=0 mult=1 m=1
XMP3 VREF PG VDD VDD sky130_fd_pr__pfet_g5v0d10v5 L=4u W=8u nf=1 ad=2.32 as=2.32 pd=16.58 ps=16.58 nrd=0.03625 nrs=0.03625 sa=0 sb=0
+ sd=0 mult=1 m=1
XMPBN NBG PG VDD VDD sky130_fd_pr__pfet_g5v0d10v5 L=4u W=2u nf=1 ad=0.58 as=0.58 pd=4.58 ps=4.58 nrd=0.145 nrs=0.145 sa=0 sb=0 sd=0
+ mult=1 m=1
XQ1 VSS VSS NA sky130_fd_pr__pnp_05v5_W3p40L3p40 m=1 mult=1
XRT NBTOP NB VSS sky130_fd_pr__res_xhigh_po W=2u L=17.5u mult=1 m=1
XR1 NB EC VSS sky130_fd_pr__res_xhigh_po W=2u L=350.0u mult=1 m=1
XQ8A VSS VSS EC sky130_fd_pr__pnp_05v5_W3p40L3p40 m=1 mult=1
XQ8B VSS VSS EC sky130_fd_pr__pnp_05v5_W3p40L3p40 m=1 mult=1
XQ8C VSS VSS EC sky130_fd_pr__pnp_05v5_W3p40L3p40 m=1 mult=1
XQ8D VSS VSS EC sky130_fd_pr__pnp_05v5_W3p40L3p40 m=1 mult=1
XQ8E VSS VSS EC sky130_fd_pr__pnp_05v5_W3p40L3p40 m=1 mult=1
XQ8F VSS VSS EC sky130_fd_pr__pnp_05v5_W3p40L3p40 m=1 mult=1
XQ8G VSS VSS EC sky130_fd_pr__pnp_05v5_W3p40L3p40 m=1 mult=1
XQ8H VSS VSS EC sky130_fd_pr__pnp_05v5_W3p40L3p40 m=1 mult=1
XR2 VREF ER VSS sky130_fd_pr__res_xhigh_po W=2u L=4104.0u mult=1 m=1
XQR VSS VSS ER sky130_fd_pr__pnp_05v5_W3p40L3p40 m=1 mult=1
XMBN NBG NBG VSS VSS sky130_fd_pr__nfet_g5v0d10v5 L=4u W=2u nf=1 ad=0.58 as=0.58 pd=4.58 ps=4.58 nrd=0.145 nrs=0.145 sa=0 sb=0 sd=0
+ mult=1 m=1
XMBN2 PB NBG VSS VSS sky130_fd_pr__nfet_g5v0d10v5 L=4u W=2u nf=1 ad=0.58 as=0.58 pd=4.58 ps=4.58 nrd=0.145 nrs=0.145 sa=0 sb=0 sd=0
+ mult=1 m=1
XMBP PB PB VDD VDD sky130_fd_pr__pfet_g5v0d10v5 L=4u W=2u nf=1 ad=0.58 as=0.58 pd=4.58 ps=4.58 nrd=0.145 nrs=0.145 sa=0 sb=0 sd=0
+ mult=1 m=1
XMPIB IBIAS PB VDD VDD sky130_fd_pr__pfet_g5v0d10v5 L=4u W=40u nf=1 ad=11.6 as=11.6 pd=80.58 ps=80.58 nrd=0.00725 nrs=0.00725 sa=0
+ sb=0 sd=0 mult=1 m=1
XMPT NT PB VDD VDD sky130_fd_pr__pfet_g5v0d10v5 L=4u W=2u nf=1 ad=0.58 as=0.58 pd=4.58 ps=4.58 nrd=0.145 nrs=0.145 sa=0 sb=0 sd=0
+ mult=1 m=1
XMI1 N1 NA NT VDD sky130_fd_pr__pfet_g5v0d10v5 L=4u W=16u nf=1 ad=4.64 as=4.64 pd=32.58 ps=32.58 nrd=0.018125 nrs=0.018125 sa=0 sb=0
+ sd=0 mult=1 m=1
XMI2 N2 NB NT VDD sky130_fd_pr__pfet_g5v0d10v5 L=4u W=16u nf=1 ad=4.64 as=4.64 pd=32.58 ps=32.58 nrd=0.018125 nrs=0.018125 sa=0 sb=0
+ sd=0 mult=1 m=1
XML1 N1 N1 VSS VSS sky130_fd_pr__nfet_g5v0d10v5 L=8u W=4u nf=1 ad=1.16 as=1.16 pd=8.58 ps=8.58 nrd=0.0725 nrs=0.0725 sa=0 sb=0 sd=0
+ mult=1 m=1
XML2 N2 N1 VSS VSS sky130_fd_pr__nfet_g5v0d10v5 L=8u W=4u nf=1 ad=1.16 as=1.16 pd=8.58 ps=8.58 nrd=0.0725 nrs=0.0725 sa=0 sb=0 sd=0
+ mult=1 m=1
XMS2N PG N2 VSS VSS sky130_fd_pr__nfet_g5v0d10v5 L=8u W=8u nf=1 ad=2.32 as=2.32 pd=16.58 ps=16.58 nrd=0.03625 nrs=0.03625 sa=0 sb=0
+ sd=0 mult=1 m=1
XMS2P PG PB VDD VDD sky130_fd_pr__pfet_g5v0d10v5 L=4u W=2u nf=1 ad=0.58 as=0.58 pd=4.58 ps=4.58 nrd=0.145 nrs=0.145 sa=0 sb=0 sd=0
+ mult=1 m=1
XCC PG NZ sky130_fd_pr__cap_mim_m3_1 W=20u L=20u MF=1 m=1
XRZ NZ N2 VSS sky130_fd_pr__res_xhigh_po W=2u L=1016.0u mult=1 m=1
XKS0 VDD VDD KS1 VSS sky130_fd_pr__nfet_g5v0d10v5 L=8u W=1u nf=1 ad=0.29 as=0.29 pd=2.58 ps=2.58 nrd=0.29 nrs=0.29 sa=0 sb=0 sd=0
+ mult=1 m=1
XKS1 KS1 KS1 KS2 VSS sky130_fd_pr__nfet_g5v0d10v5 L=8u W=1u nf=1 ad=0.29 as=0.29 pd=2.58 ps=2.58 nrd=0.29 nrs=0.29 sa=0 sb=0 sd=0
+ mult=1 m=1
XKS2 KS2 KS2 KS3 VSS sky130_fd_pr__nfet_g5v0d10v5 L=8u W=1u nf=1 ad=0.29 as=0.29 pd=2.58 ps=2.58 nrd=0.29 nrs=0.29 sa=0 sb=0 sd=0
+ mult=1 m=1
XKS3 KS3 KS3 KS4 VSS sky130_fd_pr__nfet_g5v0d10v5 L=8u W=1u nf=1 ad=0.29 as=0.29 pd=2.58 ps=2.58 nrd=0.29 nrs=0.29 sa=0 sb=0 sd=0
+ mult=1 m=1
XKS4 KS4 KS4 NKG VSS sky130_fd_pr__nfet_g5v0d10v5 L=8u W=1u nf=1 ad=0.29 as=0.29 pd=2.58 ps=2.58 nrd=0.29 nrs=0.29 sa=0 sb=0 sd=0
+ mult=1 m=1
XKA NKM PB VDD VDD sky130_fd_pr__pfet_g5v0d10v5 L=4u W=1u nf=1 ad=0.29 as=0.29 pd=2.58 ps=2.58 nrd=0.29 nrs=0.29 sa=0 sb=0 sd=0
+ mult=1 m=1
XKAN NKM NKM VSS VSS sky130_fd_pr__nfet_g5v0d10v5 L=4u W=2u nf=1 ad=0.58 as=0.58 pd=4.58 ps=4.58 nrd=0.145 nrs=0.145 sa=0 sb=0 sd=0
+ mult=1 m=1
XKPD NKG NKM VSS VSS sky130_fd_pr__nfet_g5v0d10v5 L=4u W=8u nf=1 ad=2.32 as=2.32 pd=16.58 ps=16.58 nrd=0.03625 nrs=0.03625 sa=0 sb=0
+ sd=0 mult=1 m=1
XKICK PG NKG VSS VSS sky130_fd_pr__nfet_g5v0d10v5 L=4u W=1u nf=1 ad=0.29 as=0.29 pd=2.58 ps=2.58 nrd=0.29 nrs=0.29 sa=0 sb=0 sd=0
+ mult=1 m=1
XMPOK TOK PB VDD VDD sky130_fd_pr__pfet_g5v0d10v5 L=4u W=1u nf=1 ad=0.29 as=0.29 pd=2.58 ps=2.58 nrd=0.29 nrs=0.29 sa=0 sb=0 sd=0
+ mult=1 m=1
XMOKA NOKO NA TOK VDD sky130_fd_pr__pfet_g5v0d10v5 L=4u W=8u nf=1 ad=2.32 as=2.32 pd=16.58 ps=16.58 nrd=0.03625 nrs=0.03625 sa=0
+ sb=0 sd=0 mult=1 m=1
XMOKB NOKL NBTOP TOK VDD sky130_fd_pr__pfet_g5v0d10v5 L=4u W=8u nf=1 ad=2.32 as=2.32 pd=16.58 ps=16.58 nrd=0.03625 nrs=0.03625 sa=0
+ sb=0 sd=0 mult=1 m=1
XMOL1 NOKL NOKL VSS VSS sky130_fd_pr__nfet_g5v0d10v5 L=4u W=2u nf=1 ad=0.58 as=0.58 pd=4.58 ps=4.58 nrd=0.145 nrs=0.145 sa=0 sb=0
+ sd=0 mult=1 m=1
XMOL2 NOKO NOKL VSS VSS sky130_fd_pr__nfet_g5v0d10v5 L=4u W=2u nf=1 ad=0.58 as=0.58 pd=4.58 ps=4.58 nrd=0.145 nrs=0.145 sa=0 sb=0
+ sd=0 mult=1 m=1
XMOKC NOKO NKG VSS VSS sky130_fd_pr__nfet_g5v0d10v5 L=1u W=2u nf=1 ad=0.58 as=0.58 pd=4.58 ps=4.58 nrd=0.145 nrs=0.145 sa=0 sb=0
+ sd=0 mult=1 m=1
XMOK2 NOKX NOKO VSS VSS sky130_fd_pr__nfet_g5v0d10v5 L=4u W=2u nf=1 ad=0.58 as=0.58 pd=4.58 ps=4.58 nrd=0.145 nrs=0.145 sa=0 sb=0
+ sd=0 mult=1 m=1
XMOK2P NOKX PB VDD VDD sky130_fd_pr__pfet_g5v0d10v5 L=4u W=1u nf=1 ad=0.29 as=0.29 pd=2.58 ps=2.58 nrd=0.29 nrs=0.29 sa=0 sb=0 sd=0
+ mult=1 m=1
XCOK VDD NOKX sky130_fd_pr__cap_mim_m3_1 W=6u L=6u MF=1 m=1
XMO1P BIAS_OK NOKX VDD VDD sky130_fd_pr__pfet_g5v0d10v5 L=4u W=1u nf=1 ad=0.29 as=0.29 pd=2.58 ps=2.58 nrd=0.29 nrs=0.29 sa=0 sb=0
+ sd=0 mult=1 m=1
XMO1N BIAS_OK NOKX VSS VSS sky130_fd_pr__nfet_g5v0d10v5 L=0.5u W=4u nf=1 ad=1.16 as=1.16 pd=8.58 ps=8.58 nrd=0.0725 nrs=0.0725 sa=0
+ sb=0 sd=0 mult=1 m=1
.ends
