* generated by sim/temp-core-accuracy-mc/run_accuracy_mc.py (term=amp, variant=chop-degen, clocked transient) -- do not edit
* variant chop-degen: mirror-degen rewrite (reused: XMP1..3 L4 W32 + XRDEG1..3 in the `mirror` group) plus a chopped amplifier: XMI1/XMI2 re-wired (drains N1/N2 -> ND1/ND2, gates NA/NB -> NGA1/NGA2) behind cross-coupled transmission-gate choppers XSWI1..4 (input, NA/NB to NGA1/NGA2) and XSWO1..4 (output, ND1/ND2 to N1/N2), nfet+pfet pass halves sky130_fd_pr__{n,p}fet_g5v0d10v5 L=0.5 W=2, controlled by CHA/CHAB and CHB/CHBB; phase A connects straight through, phase B crosses both choppers (loop polarity unchanged, amplifier offset sign flipped); the 16 switch instances are part of the `amp` mismatch group
* Clocked chopping transient (make-before-break overlap); EN tied to VDD; bias_core + temp_core as in the #86 solver bench.
* ng_nomodcheck: carried in the netlist because the fleet runner ignores options.ngspice_init
.control
set ng_nomodcheck
.endc
.options wnflag=1 method=gear
VSUP VDD 0 3.3
XBIAS VDD 0 IBIAS VREF BIAS_OK bias_core
XDUT VDD 0 IBIAS VDD PTAT CTAT temp_core

.subckt mmoff_pfet d g s b l=1 w=1 nf=1 ad=0 as=0 pd=0 ps=0 nrd=0 nrs=0 sa=0 sb=0 sd=0 mult=1
.param sw_mm_vth0_sky130_fd_pr__pfet_g5v0d10v5=0
Xi d g s b sky130_fd_pr__pfet_g5v0d10v5 l={l} w={w} nf={nf} ad={ad} as={as} pd={pd} ps={ps} nrd={nrd} nrs={nrs} sa={sa} sb={sb} sd={sd} mult={mult}
.ends

.subckt mmoff_nfet d g s b l=1 w=1 nf=1 ad=0 as=0 pd=0 ps=0 nrd=0 nrs=0 sa=0 sb=0 sd=0 mult=1
.param sw_mm_vth0_sky130_fd_pr__nfet_g5v0d10v5=0
Xi d g s b sky130_fd_pr__nfet_g5v0d10v5 l={l} w={w} nf={nf} ad={ad} as={as} pd={pd} ps={ps} nrd={nrd} nrs={nrs} sa={sa} sb={sb} sd={sd} mult={mult}
.ends

.subckt mmoff_pnp c b e mult=1
.param sw_mm_sky130_fd_pr__pnp_05v5_W0p68L0p68_is=0 sw_mm_sky130_fd_pr__pnp_05v5_W0p68L0p68_bf=0
Xi c b e sky130_fd_pr__pnp_05v5_W3p40L3p40 mult={mult}
.ends

.subckt mmoff_res r0 r1 sub w=1 l=1 mult=1
.param sw_mm_sky130_fd_pr__res_xhigh_po=0 sw_mm_sky130_fd_pr__res_generic_po_head=0
Xi r0 r1 sub sky130_fd_pr__res_xhigh_po w={w} l={l} mult={mult}
.ends

.subckt mmoff_cap c0 c1 w=1 l=1 mult=1 mf=1
.param sw_mm_cmim=0
Xi c0 c1 sky130_fd_pr__cap_mim_m3_1 w={w} l={l} mult={mult}
.ends

* bias_core -- generated by design/netlist.py from design/bias_core.sch
* Do not edit: edit the schematic and re-run the export.
** sch_path: design/bias_core.sch
.subckt bias_core VDD VSS IBIAS VREF BIAS_OK
*.PININFO VDD:B VSS:B IBIAS:O VREF:O BIAS_OK:O
XMP1 NA PG VDD VDD mmoff_pfet L=4 W=8 nf=1 ad=2.32 as=2.32 pd=16.58 ps=16.58 nrd=0.03625 nrs=0.03625 sa=0 sb=0 sd=0 mult=1 m=1
XMP2 NBTOP PG VDD VDD mmoff_pfet L=4 W=8 nf=1 ad=2.32 as=2.32 pd=16.58 ps=16.58 nrd=0.03625 nrs=0.03625 sa=0 sb=0 sd=0 mult=1 m=1
XMP3 VREF PG VDD VDD mmoff_pfet L=4 W=8 nf=1 ad=2.32 as=2.32 pd=16.58 ps=16.58 nrd=0.03625 nrs=0.03625 sa=0 sb=0 sd=0 mult=1 m=1
XMPBN NBG PG VDD VDD mmoff_pfet L=4 W=2 nf=1 ad=0.58 as=0.58 pd=4.58 ps=4.58 nrd=0.145 nrs=0.145 sa=0 sb=0 sd=0 mult=1 m=1
XQ1 VSS VSS NA mmoff_pnp m=1 mult=1
XRT NBTOP NB VSS mmoff_res W=2 L=17.5 mult=1 m=1
XR1 NB EC VSS mmoff_res W=2 L=350.0 mult=1 m=1
XQ8A VSS VSS EC mmoff_pnp m=1 mult=1
XQ8B VSS VSS EC mmoff_pnp m=1 mult=1
XQ8C VSS VSS EC mmoff_pnp m=1 mult=1
XQ8D VSS VSS EC mmoff_pnp m=1 mult=1
XQ8E VSS VSS EC mmoff_pnp m=1 mult=1
XQ8F VSS VSS EC mmoff_pnp m=1 mult=1
XQ8G VSS VSS EC mmoff_pnp m=1 mult=1
XQ8H VSS VSS EC mmoff_pnp m=1 mult=1
XR2 VREF ER VSS mmoff_res W=2 L=4104.0 mult=1 m=1
XQR VSS VSS ER mmoff_pnp m=1 mult=1
XMBN NBG NBG VSS VSS mmoff_nfet L=4 W=2 nf=1 ad=0.58 as=0.58 pd=4.58 ps=4.58 nrd=0.145 nrs=0.145 sa=0 sb=0 sd=0 mult=1 m=1
XMBN2 PB NBG VSS VSS mmoff_nfet L=4 W=2 nf=1 ad=0.58 as=0.58 pd=4.58 ps=4.58 nrd=0.145 nrs=0.145 sa=0 sb=0 sd=0 mult=1 m=1
XMBP PB PB VDD VDD mmoff_pfet L=4 W=2 nf=1 ad=0.58 as=0.58 pd=4.58 ps=4.58 nrd=0.145 nrs=0.145 sa=0 sb=0 sd=0 mult=1 m=1
XMPIB IBIAS PB VDD VDD mmoff_pfet L=4 W=40 nf=1 ad=11.6 as=11.6 pd=80.58 ps=80.58 nrd=0.00725 nrs=0.00725 sa=0 sb=0 sd=0 mult=1 m=1
XMPT NT PB VDD VDD mmoff_pfet L=4 W=2 nf=1 ad=0.58 as=0.58 pd=4.58 ps=4.58 nrd=0.145 nrs=0.145 sa=0 sb=0 sd=0 mult=1 m=1
XMI1 N1 NA NT VDD mmoff_pfet L=4 W=16 nf=1 ad=4.64 as=4.64 pd=32.58 ps=32.58 nrd=0.018125 nrs=0.018125 sa=0 sb=0 sd=0 mult=1 m=1
XMI2 N2 NB NT VDD mmoff_pfet L=4 W=16 nf=1 ad=4.64 as=4.64 pd=32.58 ps=32.58 nrd=0.018125 nrs=0.018125 sa=0 sb=0 sd=0 mult=1 m=1
XML1 N1 N1 VSS VSS mmoff_nfet L=8 W=4 nf=1 ad=1.16 as=1.16 pd=8.58 ps=8.58 nrd=0.0725 nrs=0.0725 sa=0 sb=0 sd=0 mult=1 m=1
XML2 N2 N1 VSS VSS mmoff_nfet L=8 W=4 nf=1 ad=1.16 as=1.16 pd=8.58 ps=8.58 nrd=0.0725 nrs=0.0725 sa=0 sb=0 sd=0 mult=1 m=1
XMS2N PG N2 VSS VSS mmoff_nfet L=8 W=8 nf=1 ad=2.32 as=2.32 pd=16.58 ps=16.58 nrd=0.03625 nrs=0.03625 sa=0 sb=0 sd=0 mult=1 m=1
XMS2P PG PB VDD VDD mmoff_pfet L=4 W=2 nf=1 ad=0.58 as=0.58 pd=4.58 ps=4.58 nrd=0.145 nrs=0.145 sa=0 sb=0 sd=0 mult=1 m=1
XCC PG NZ mmoff_cap W=20 L=20 MF=1 m=1
XRZ NZ N2 VSS mmoff_res W=2 L=1016.0 mult=1 m=1
XKS0 VDD VDD KS1 VSS mmoff_nfet L=8 W=1 nf=1 ad=0.29 as=0.29 pd=2.58 ps=2.58 nrd=0.29 nrs=0.29 sa=0 sb=0 sd=0 mult=1 m=1
XKS1 KS1 KS1 KS2 VSS mmoff_nfet L=8 W=1 nf=1 ad=0.29 as=0.29 pd=2.58 ps=2.58 nrd=0.29 nrs=0.29 sa=0 sb=0 sd=0 mult=1 m=1
XKS2 KS2 KS2 KS3 VSS mmoff_nfet L=8 W=1 nf=1 ad=0.29 as=0.29 pd=2.58 ps=2.58 nrd=0.29 nrs=0.29 sa=0 sb=0 sd=0 mult=1 m=1
XKS3 KS3 KS3 KS4 VSS mmoff_nfet L=8 W=1 nf=1 ad=0.29 as=0.29 pd=2.58 ps=2.58 nrd=0.29 nrs=0.29 sa=0 sb=0 sd=0 mult=1 m=1
XKS4 KS4 KS4 NKG VSS mmoff_nfet L=8 W=1 nf=1 ad=0.29 as=0.29 pd=2.58 ps=2.58 nrd=0.29 nrs=0.29 sa=0 sb=0 sd=0 mult=1 m=1
XKA NKM PB VDD VDD mmoff_pfet L=4 W=1 nf=1 ad=0.29 as=0.29 pd=2.58 ps=2.58 nrd=0.29 nrs=0.29 sa=0 sb=0 sd=0 mult=1 m=1
XKAN NKM NKM VSS VSS mmoff_nfet L=4 W=2 nf=1 ad=0.58 as=0.58 pd=4.58 ps=4.58 nrd=0.145 nrs=0.145 sa=0 sb=0 sd=0 mult=1 m=1
XKPD NKG NKM VSS VSS mmoff_nfet L=4 W=8 nf=1 ad=2.32 as=2.32 pd=16.58 ps=16.58 nrd=0.03625 nrs=0.03625 sa=0 sb=0 sd=0 mult=1 m=1
XKICK PG NKG VSS VSS mmoff_nfet L=4 W=1 nf=1 ad=0.29 as=0.29 pd=2.58 ps=2.58 nrd=0.29 nrs=0.29 sa=0 sb=0 sd=0 mult=1 m=1
XMPOK TOK PB VDD VDD mmoff_pfet L=4 W=1 nf=1 ad=0.29 as=0.29 pd=2.58 ps=2.58 nrd=0.29 nrs=0.29 sa=0 sb=0 sd=0 mult=1 m=1
XMOKA NOKO NA TOK VDD mmoff_pfet L=4 W=8 nf=1 ad=2.32 as=2.32 pd=16.58 ps=16.58 nrd=0.03625 nrs=0.03625 sa=0 sb=0 sd=0 mult=1 m=1
XMOKB NOKL NBTOP TOK VDD mmoff_pfet L=4 W=8 nf=1 ad=2.32 as=2.32 pd=16.58 ps=16.58 nrd=0.03625 nrs=0.03625 sa=0 sb=0 sd=0 mult=1 m=1
XMOL1 NOKL NOKL VSS VSS mmoff_nfet L=4 W=2 nf=1 ad=0.58 as=0.58 pd=4.58 ps=4.58 nrd=0.145 nrs=0.145 sa=0 sb=0 sd=0 mult=1 m=1
XMOL2 NOKO NOKL VSS VSS mmoff_nfet L=4 W=2 nf=1 ad=0.58 as=0.58 pd=4.58 ps=4.58 nrd=0.145 nrs=0.145 sa=0 sb=0 sd=0 mult=1 m=1
XMOKC NOKO NKG VSS VSS mmoff_nfet L=1 W=2 nf=1 ad=0.58 as=0.58 pd=4.58 ps=4.58 nrd=0.145 nrs=0.145 sa=0 sb=0 sd=0 mult=1 m=1
XMOK2 NOKX NOKO VSS VSS mmoff_nfet L=4 W=2 nf=1 ad=0.58 as=0.58 pd=4.58 ps=4.58 nrd=0.145 nrs=0.145 sa=0 sb=0 sd=0 mult=1 m=1
XMOK2P NOKX PB VDD VDD mmoff_pfet L=4 W=1 nf=1 ad=0.29 as=0.29 pd=2.58 ps=2.58 nrd=0.29 nrs=0.29 sa=0 sb=0 sd=0 mult=1 m=1
XCOK VDD NOKX mmoff_cap W=6 L=6 MF=1 m=1
XMO1P BIAS_OK NOKX VDD VDD mmoff_pfet L=4 W=1 nf=1 ad=0.29 as=0.29 pd=2.58 ps=2.58 nrd=0.29 nrs=0.29 sa=0 sb=0 sd=0 mult=1 m=1
XMO1N BIAS_OK NOKX VSS VSS mmoff_nfet L=0.5 W=4 nf=1 ad=1.16 as=1.16 pd=8.58 ps=8.58 nrd=0.0725 nrs=0.0725 sa=0 sb=0 sd=0 mult=1 m=1
.ends

* temp_core -- generated by design/netlist.py from design/temp_core.sch
* Do not edit: edit the schematic and re-run the export.
** sch_path: design/temp_core.sch
.subckt temp_core VDD VSS IBIAS EN PTAT CTAT
*.PININFO VDD:B VSS:B IBIAS:I EN:I PTAT:O CTAT:O
XMBD IBIAS NBG VSS VSS mmoff_nfet L=2 W=4 nf=1 ad=1.16 as=1.16 pd=8.58 ps=8.58 nrd=0.0725 nrs=0.0725 sa=0 sb=0 sd=0 mult=1 m=1
XMPASS IBIAS EN NBG VSS mmoff_nfet L=0.5 W=2 nf=1 ad=0.58 as=0.58 pd=4.58 ps=4.58 nrd=0.145 nrs=0.145 sa=0 sb=0 sd=0 mult=1 m=1
XMDNB NBG ENB VSS VSS mmoff_nfet L=0.5 W=2 nf=1 ad=0.58 as=0.58 pd=4.58 ps=4.58 nrd=0.145 nrs=0.145 sa=0 sb=0 sd=0 mult=1 m=1
XMBN1 PB NBG VSS VSS mmoff_nfet L=2 W=4 nf=1 ad=1.16 as=1.16 pd=8.58 ps=8.58 nrd=0.0725 nrs=0.0725 sa=0 sb=0 sd=0 mult=1 m=1
XMBP PB PB VDD VDD mmoff_pfet L=4 W=10 nf=1 ad=2.9 as=2.9 pd=20.58 ps=20.58 nrd=0.029 nrs=0.029 sa=0 sb=0 sd=0 mult=1 m=1
XMBN2 PCAS NBG VSS VSS mmoff_nfet L=2 W=4 nf=1 ad=1.16 as=1.16 pd=8.58 ps=8.58 nrd=0.0725 nrs=0.0725 sa=0 sb=0 sd=0 mult=1 m=1
XMCB PCAS PCAS VDD VDD mmoff_pfet L=8 W=1 nf=1 ad=0.29 as=0.29 pd=2.58 ps=2.58 nrd=0.29 nrs=0.29 sa=0 sb=0 sd=0 mult=1 m=1
XMINVP ENB EN VDD VDD mmoff_pfet L=0.5 W=2 nf=1 ad=0.58 as=0.58 pd=4.58 ps=4.58 nrd=0.145 nrs=0.145 sa=0 sb=0 sd=0 mult=1 m=1
XMINVN ENB EN VSS VSS mmoff_nfet L=0.5 W=1 nf=1 ad=0.29 as=0.29 pd=2.58 ps=2.58 nrd=0.29 nrs=0.29 sa=0 sb=0 sd=0 mult=1 m=1
XMT NT PB VDD VDD mmoff_pfet L=4 W=20 nf=1 ad=5.8 as=5.8 pd=40.58 ps=40.58 nrd=0.0145 nrs=0.0145 sa=0 sb=0 sd=0 mult=1 m=1
XMI1 ND1 NGA1 NT NT sky130_fd_pr__pfet_g5v0d10v5 L=4 W=32 nf=1 ad=9.28 as=9.28 pd=64.58 ps=64.58 nrd=0.0090625 nrs=0.0090625 sa=0 sb=0 sd=0 mult=1 m=1
XMI2 ND2 NGA2 NT NT sky130_fd_pr__pfet_g5v0d10v5 L=4 W=32 nf=1 ad=9.28 as=9.28 pd=64.58 ps=64.58 nrd=0.0090625 nrs=0.0090625 sa=0 sb=0 sd=0 mult=1 m=1
XML1 N1 N1 VSS VSS sky130_fd_pr__nfet_g5v0d10v5 L=8 W=8 nf=1 ad=2.32 as=2.32 pd=16.58 ps=16.58 nrd=0.03625 nrs=0.03625 sa=0 sb=0 sd=0 mult=1 m=1
XML2 N2 N1 VSS VSS sky130_fd_pr__nfet_g5v0d10v5 L=8 W=8 nf=1 ad=2.32 as=2.32 pd=16.58 ps=16.58 nrd=0.03625 nrs=0.03625 sa=0 sb=0 sd=0 mult=1 m=1
XMS2N PG N2 VSS VSS mmoff_nfet L=8 W=8 nf=1 ad=2.32 as=2.32 pd=16.58 ps=16.58 nrd=0.03625 nrs=0.03625 sa=0 sb=0 sd=0 mult=1 m=1
XMS2P PG PB VDD VDD mmoff_pfet L=4 W=10 nf=1 ad=2.9 as=2.9 pd=20.58 ps=20.58 nrd=0.029 nrs=0.029 sa=0 sb=0 sd=0 mult=1 m=1
XCC PG NZ mmoff_cap W=12 L=12 MF=1 m=1
XRZ NZ N2 VSS mmoff_res W=2 L=1000 mult=1 m=1
XMP1 M1D PG SDG1 VDD mmoff_pfet L=4 W=32 nf=1 ad=9.28 as=9.28 pd=64.58 ps=64.58 nrd=0.0090625 nrs=0.0090625 sa=0 sb=0 sd=0 mult=1 m=1
XRDEG1 VDD SDG1 VSS mmoff_res W=2 L=660 mult=1 m=1
XMPC1 NA PCAS M1D VDD mmoff_pfet L=1 W=8 nf=1 ad=2.32 as=2.32 pd=16.58 ps=16.58 nrd=0.03625 nrs=0.03625 sa=0 sb=0 sd=0 mult=1 m=1
XMP2 M2D PG SDG2 VDD mmoff_pfet L=4 W=32 nf=1 ad=9.28 as=9.28 pd=64.58 ps=64.58 nrd=0.0090625 nrs=0.0090625 sa=0 sb=0 sd=0 mult=1 m=1
XRDEG2 VDD SDG2 VSS mmoff_res W=2 L=660 mult=1 m=1
XMPC2 NB PCAS M2D VDD mmoff_pfet L=1 W=8 nf=1 ad=2.32 as=2.32 pd=16.58 ps=16.58 nrd=0.03625 nrs=0.03625 sa=0 sb=0 sd=0 mult=1 m=1
XMP3 M3D PG SDG3 VDD mmoff_pfet L=4 W=32 nf=1 ad=9.28 as=9.28 pd=64.58 ps=64.58 nrd=0.0090625 nrs=0.0090625 sa=0 sb=0 sd=0 mult=1 m=1
XRDEG3 VDD SDG3 VSS mmoff_res W=2 L=660 mult=1 m=1
XMPC3 PTAT PCAS M3D VDD mmoff_pfet L=1 W=8 nf=1 ad=2.32 as=2.32 pd=16.58 ps=16.58 nrd=0.03625 nrs=0.03625 sa=0 sb=0 sd=0 mult=1 m=1
XMSU1 ND PB VDD VDD mmoff_pfet L=8 W=1 nf=1 ad=0.29 as=0.29 pd=2.58 ps=2.58 nrd=0.29 nrs=0.29 sa=0 sb=0 sd=0 mult=1 m=1
XMSU2 ND NR VSS VSS mmoff_nfet L=2 W=2 nf=1 ad=0.58 as=0.58 pd=4.58 ps=4.58 nrd=0.145 nrs=0.145 sa=0 sb=0 sd=0 mult=1 m=1
XMSU3 PG ND VSS VSS mmoff_nfet L=1 W=4 nf=1 ad=1.16 as=1.16 pd=8.58 ps=8.58 nrd=0.0725 nrs=0.0725 sa=0 sb=0 sd=0 mult=1 m=1
XMDND ND ENB VSS VSS mmoff_nfet L=0.5 W=2 nf=1 ad=0.58 as=0.58 pd=4.58 ps=4.58 nrd=0.145 nrs=0.145 sa=0 sb=0 sd=0 mult=1 m=1
XMENPG PG EN VDD VDD mmoff_pfet L=0.5 W=4 nf=1 ad=1.16 as=1.16 pd=8.58 ps=8.58 nrd=0.0725 nrs=0.0725 sa=0 sb=0 sd=0 mult=1 m=1
XMENPT PTAT ENB VSS VSS mmoff_nfet L=1 W=1 nf=1 ad=0.29 as=0.29 pd=2.58 ps=2.58 nrd=0.29 nrs=0.29 sa=0 sb=0 sd=0 mult=1 m=1
XMENCT CTAT ENB VSS VSS mmoff_nfet L=1 W=1 nf=1 ad=0.29 as=0.29 pd=2.58 ps=2.58 nrd=0.29 nrs=0.29 sa=0 sb=0 sd=0 mult=1 m=1
XMSU4 NR PG VDD VDD mmoff_pfet L=4 W=1 nf=1 ad=0.29 as=0.29 pd=2.58 ps=2.58 nrd=0.29 nrs=0.29 sa=0 sb=0 sd=0 mult=1 m=1
XMSU5 NR NR VSS VSS mmoff_nfet L=2 W=2 nf=1 ad=0.58 as=0.58 pd=4.58 ps=4.58 nrd=0.145 nrs=0.145 sa=0 sb=0 sd=0 mult=1 m=1
XMDN2 N2 ENB VSS VSS mmoff_nfet L=1 W=2 nf=1 ad=0.58 as=0.58 pd=4.58 ps=4.58 nrd=0.145 nrs=0.145 sa=0 sb=0 sd=0 mult=1 m=1
XMDNT NT ENB VSS VSS mmoff_nfet L=1 W=2 nf=1 ad=0.58 as=0.58 pd=4.58 ps=4.58 nrd=0.145 nrs=0.145 sa=0 sb=0 sd=0 mult=1 m=1
XQ1 VSS VSS NA mmoff_pnp m=1 mult=1
XQ8A VSS VSS NC mmoff_pnp m=1 mult=1
XQ8B VSS VSS NC mmoff_pnp m=1 mult=1
XQ8C VSS VSS NC mmoff_pnp m=1 mult=1
XQ8D VSS VSS NC mmoff_pnp m=1 mult=1
XQ8E VSS VSS NC mmoff_pnp m=1 mult=1
XQ8F VSS VSS NC mmoff_pnp m=1 mult=1
XQ8G VSS VSS NC mmoff_pnp m=1 mult=1
XQ8H VSS VSS NC mmoff_pnp m=1 mult=1
XR1 NB NC VSS mmoff_res W=2 L=119.47 mult=1 m=1
XR2 PTAT PTAT_TRIM VSS mmoff_res W=2 L=2652.6 mult=1 m=1
XR2TRIM PTAT_TRIM VSS VSS mmoff_res W=2 L=450.88 mult=1 m=1
XRISO NA CTAT VSS mmoff_res W=2 L=111.05 mult=1 m=1
XSWI1N NA CHA NGA1 VSS sky130_fd_pr__nfet_g5v0d10v5 L=0.5 W=2 nf=1 ad=0.58 as=0.58 pd=4.58 ps=4.58 nrd=0.145 nrs=0.145 sa=0 sb=0 sd=0 mult=1 m=1
XSWI1P NA CHAB NGA1 VDD sky130_fd_pr__pfet_g5v0d10v5 L=0.5 W=2 nf=1 ad=0.58 as=0.58 pd=4.58 ps=4.58 nrd=0.145 nrs=0.145 sa=0 sb=0 sd=0 mult=1 m=1
XSWI2N NB CHA NGA2 VSS sky130_fd_pr__nfet_g5v0d10v5 L=0.5 W=2 nf=1 ad=0.58 as=0.58 pd=4.58 ps=4.58 nrd=0.145 nrs=0.145 sa=0 sb=0 sd=0 mult=1 m=1
XSWI2P NB CHAB NGA2 VDD sky130_fd_pr__pfet_g5v0d10v5 L=0.5 W=2 nf=1 ad=0.58 as=0.58 pd=4.58 ps=4.58 nrd=0.145 nrs=0.145 sa=0 sb=0 sd=0 mult=1 m=1
XSWI3N NA CHB NGA2 VSS sky130_fd_pr__nfet_g5v0d10v5 L=0.5 W=2 nf=1 ad=0.58 as=0.58 pd=4.58 ps=4.58 nrd=0.145 nrs=0.145 sa=0 sb=0 sd=0 mult=1 m=1
XSWI3P NA CHBB NGA2 VDD sky130_fd_pr__pfet_g5v0d10v5 L=0.5 W=2 nf=1 ad=0.58 as=0.58 pd=4.58 ps=4.58 nrd=0.145 nrs=0.145 sa=0 sb=0 sd=0 mult=1 m=1
XSWI4N NB CHB NGA1 VSS sky130_fd_pr__nfet_g5v0d10v5 L=0.5 W=2 nf=1 ad=0.58 as=0.58 pd=4.58 ps=4.58 nrd=0.145 nrs=0.145 sa=0 sb=0 sd=0 mult=1 m=1
XSWI4P NB CHBB NGA1 VDD sky130_fd_pr__pfet_g5v0d10v5 L=0.5 W=2 nf=1 ad=0.58 as=0.58 pd=4.58 ps=4.58 nrd=0.145 nrs=0.145 sa=0 sb=0 sd=0 mult=1 m=1
XSWO1N ND1 CHA N1 VSS sky130_fd_pr__nfet_g5v0d10v5 L=0.5 W=2 nf=1 ad=0.58 as=0.58 pd=4.58 ps=4.58 nrd=0.145 nrs=0.145 sa=0 sb=0 sd=0 mult=1 m=1
XSWO1P ND1 CHAB N1 VDD sky130_fd_pr__pfet_g5v0d10v5 L=0.5 W=2 nf=1 ad=0.58 as=0.58 pd=4.58 ps=4.58 nrd=0.145 nrs=0.145 sa=0 sb=0 sd=0 mult=1 m=1
XSWO2N ND2 CHA N2 VSS sky130_fd_pr__nfet_g5v0d10v5 L=0.5 W=2 nf=1 ad=0.58 as=0.58 pd=4.58 ps=4.58 nrd=0.145 nrs=0.145 sa=0 sb=0 sd=0 mult=1 m=1
XSWO2P ND2 CHAB N2 VDD sky130_fd_pr__pfet_g5v0d10v5 L=0.5 W=2 nf=1 ad=0.58 as=0.58 pd=4.58 ps=4.58 nrd=0.145 nrs=0.145 sa=0 sb=0 sd=0 mult=1 m=1
XSWO3N ND1 CHB N2 VSS sky130_fd_pr__nfet_g5v0d10v5 L=0.5 W=2 nf=1 ad=0.58 as=0.58 pd=4.58 ps=4.58 nrd=0.145 nrs=0.145 sa=0 sb=0 sd=0 mult=1 m=1
XSWO3P ND1 CHBB N2 VDD sky130_fd_pr__pfet_g5v0d10v5 L=0.5 W=2 nf=1 ad=0.58 as=0.58 pd=4.58 ps=4.58 nrd=0.145 nrs=0.145 sa=0 sb=0 sd=0 mult=1 m=1
XSWO4N ND2 CHB N1 VSS sky130_fd_pr__nfet_g5v0d10v5 L=0.5 W=2 nf=1 ad=0.58 as=0.58 pd=4.58 ps=4.58 nrd=0.145 nrs=0.145 sa=0 sb=0 sd=0 mult=1 m=1
XSWO4P ND2 CHBB N1 VDD sky130_fd_pr__pfet_g5v0d10v5 L=0.5 W=2 nf=1 ad=0.58 as=0.58 pd=4.58 ps=4.58 nrd=0.145 nrs=0.145 sa=0 sb=0 sd=0 mult=1 m=1
VCKA CHA 0 PULSE(0 2.5 0 2e-07 2e-07 5.5e-05 0.0001)
VCKAB CHAB 0 PULSE(2.5 0 0 2e-07 2e-07 5.5e-05 0.0001)
VCKB CHB 0 PULSE(0 2.5 5e-05 2e-07 2e-07 5.5e-05 0.0001)
VCKBB CHBB 0 PULSE(2.5 0 5e-05 2e-07 2e-07 5.5e-05 0.0001)
.ends

.end
