* por-comparator-thresholds: generated by sim/por-comparator-thresholds/run_thresholds_campaign.py -- do not edit
* sweep rate (V/s, up and down): 100
.param rate=100
* ng_nomodcheck: same setting as sim/spiceinit; carried in the netlist because the
* fleet runner ignores options.ngspice_init (see experiment.json ngspice_note)
.control
set ng_nomodcheck
.endc
** klt-netlist-inputs: {"pdk_variant": "sky130A", "rcfile": "xschemrc", "xschem_version": "3.4.7"}
** sch_path: sim/por-comparator-thresholds/testbench/tb_por_comparator_thresholds_realbias.sch
**.subckt tb_por_comparator_thresholds_realbias
VSET VSETN 0 3.63
BVDD VDD 0 V = min(v(VSETN), min({rate}*time, max(0, 2*v(VSETN) - {rate}*time))) m=1
XDUT VDD 0 IBIAS VREF BIAS_OK POR_RAW por_comparator
XBIAS VDD 0 IBIAS VREF BIAS_OK bias_core
**** begin user architecture code

.save v(vdd) v(por_raw) v(vref) v(ibias) v(bias_ok) i(bvdd)
.save v(xdut.sns) v(xdut.snsb) v(xdut.n1) v(xdut.cmpo)
* issue #455: OK-detector internal nodes of the real bias_core, so a failed-release
* realisation can be attributed inside the settle detector (input pair / mirror / output
* stage) from per-sample node levels, not only from BIAS_OK itself
.save v(xbias.na) v(xbias.nbtop) v(xbias.pb) v(xbias.tok) v(xbias.noko) v(xbias.nokl) v(xbias.nokx) v(xbias.nkg)
.options method=gear trtol=50

**** end user architecture code
**.ends

* por_comparator -- generated by design/netlist.py from design/por_comparator.sch
* Do not edit: edit the schematic and re-run the export.
** sch_path: design/por_comparator.sch
.subckt por_comparator VDD VSS IBIAS VREF BIAS_OK POR_RAW
*.PININFO VDD:B VSS:B IBIAS:I VREF:I BIAS_OK:I POR_RAW:O
XMENP BIAS_OKB BIAS_OK VDD VDD sky130_fd_pr__pfet_g5v0d10v5 L=0.5 W=2 nf=1 ad=0.58 as=0.58 pd=4.58 ps=4.58 nrd=0.145 nrs=0.145
+ sa=0 sb=0 sd=0 mult=1 m=1
XMENN BIAS_OKB BIAS_OK VSS VSS sky130_fd_pr__nfet_g5v0d10v5 L=0.5 W=1 nf=1 ad=0.29 as=0.29 pd=2.58 ps=2.58 nrd=0.29 nrs=0.29 sa=0
+ sb=0 sd=0 mult=1 m=1
XMBD IBIAS NBG VSS VSS sky130_fd_pr__nfet_g5v0d10v5 L=2 W=2 nf=1 ad=0.58 as=0.58 pd=4.58 ps=4.58 nrd=0.145 nrs=0.145 sa=0 sb=0
+ sd=0 mult=1 m=1
XMPASS IBIAS BIAS_OK NBG VSS sky130_fd_pr__nfet_g5v0d10v5 L=0.5 W=2 nf=1 ad=0.58 as=0.58 pd=4.58 ps=4.58 nrd=0.145 nrs=0.145 sa=0
+ sb=0 sd=0 mult=1 m=1
XMDNB NBG BIAS_OKB VSS VSS sky130_fd_pr__nfet_g5v0d10v5 L=0.5 W=2 nf=1 ad=0.58 as=0.58 pd=4.58 ps=4.58 nrd=0.145 nrs=0.145 sa=0
+ sb=0 sd=0 mult=1 m=1
XMDIB IBIAS BIAS_OKB VSS VSS sky130_fd_pr__nfet_g5v0d10v5 L=1 W=1 nf=1 ad=0.29 as=0.29 pd=2.58 ps=2.58 nrd=0.29 nrs=0.29 sa=0 sb=0
+ sd=0 mult=1 m=1
XRTOP SNS VDD VSS sky130_fd_pr__res_xhigh_po W=2 L=7897.44 mult=1 m=1
XRBOT SNSB SNS VSS sky130_fd_pr__res_xhigh_po W=2 L=6769.23 mult=1 m=1
XRHYS VSS SNSB VSS sky130_fd_pr__res_xhigh_po W=2 L=775.0 mult=1 m=1
XMHSW SNSB N1 VSS VSS sky130_fd_pr__nfet_g5v0d10v5 L=0.5 W=10 nf=1 ad=2.9 as=2.9 pd=20.58 ps=20.58 nrd=0.029 nrs=0.029 sa=0 sb=0
+ sd=0 mult=1 m=1
XMTAIL TN NBG VSS VSS sky130_fd_pr__nfet_g5v0d10v5 L=10 W=1 nf=1 ad=0.29 as=0.29 pd=2.58 ps=2.58 nrd=0.29 nrs=0.29 sa=0 sb=0 sd=0
+ mult=1 m=1
XMINA NA SNS TN VSS sky130_fd_pr__nfet_g5v0d10v5 L=1 W=2 nf=1 ad=0.58 as=0.58 pd=4.58 ps=4.58 nrd=0.145 nrs=0.145 sa=0 sb=0 sd=0
+ mult=1 m=1
XMINB CMPO VREF TN VSS sky130_fd_pr__nfet_g5v0d10v5 L=1 W=2 nf=1 ad=0.58 as=0.58 pd=4.58 ps=4.58 nrd=0.145 nrs=0.145 sa=0 sb=0
+ sd=0 mult=1 m=1
XMLA NA NA VDDA VDD sky130_fd_pr__pfet_g5v0d10v5 L=1 W=4 nf=1 ad=1.16 as=1.16 pd=8.58 ps=8.58 nrd=0.0725 nrs=0.0725 sa=0 sb=0 sd=0
+ mult=1 m=1
XMLB CMPO NA VDDA VDD sky130_fd_pr__pfet_g5v0d10v5 L=1 W=4 nf=1 ad=1.16 as=1.16 pd=8.58 ps=8.58 nrd=0.0725 nrs=0.0725 sa=0 sb=0
+ sd=0 mult=1 m=1
XMENSRC VDDA BIAS_OKB VDD VDD sky130_fd_pr__pfet_g5v0d10v5 L=0.5 W=4 nf=1 ad=1.16 as=1.16 pd=8.58 ps=8.58 nrd=0.0725 nrs=0.0725
+ sa=0 sb=0 sd=0 mult=1 m=1
XMDCMPO CMPO BIAS_OKB VSS VSS sky130_fd_pr__nfet_g5v0d10v5 L=1 W=2 nf=1 ad=0.58 as=0.58 pd=4.58 ps=4.58 nrd=0.145 nrs=0.145 sa=0
+ sb=0 sd=0 mult=1 m=1
XMI1P N1 CMPO VDD VDD sky130_fd_pr__pfet_g5v0d10v5 L=0.5 W=2 nf=1 ad=0.58 as=0.58 pd=4.58 ps=4.58 nrd=0.145 nrs=0.145 sa=0 sb=0
+ sd=0 mult=1 m=1
XMI1N N1 CMPO VSS VSS sky130_fd_pr__nfet_g5v0d10v5 L=0.5 W=1 nf=1 ad=0.29 as=0.29 pd=2.58 ps=2.58 nrd=0.29 nrs=0.29 sa=0 sb=0 sd=0
+ mult=1 m=1
XMI2P POR_RAW N1 VDD VDD sky130_fd_pr__pfet_g5v0d10v5 L=0.5 W=2 nf=1 ad=0.58 as=0.58 pd=4.58 ps=4.58 nrd=0.145 nrs=0.145 sa=0 sb=0
+ sd=0 mult=1 m=1
XMI2N POR_RAW N1 VSS VSS sky130_fd_pr__nfet_g5v0d10v5 L=0.5 W=1 nf=1 ad=0.29 as=0.29 pd=2.58 ps=2.58 nrd=0.29 nrs=0.29 sa=0 sb=0
+ sd=0 mult=1 m=1
.ends
* DERIVED from bias_core.pex.spice by make_sim_netlist.py (issue #487) -- do not edit.
* edits: (1) 303 'NAME|alias' net-name aliases collapsed to NAME; (2) 35 MOS models 01v8 -> g5v0d10v5
* (layout lacks the hvi marker; see script docstring). R/C/W/L untouched; pin order already schematic order.
* extracted by klt extract --deck sky130
* parasitic model (--parasitics):
* - capacitance: net-to-ground for every net's own (non-coupled) area/perimeter, plus net-to-net for the vertical-overlap coupling `coupling` describes below -- a coupled net pair gets a direct capacitor between their two hub nodes, not just capacitors to the deck's ground/substrate net
* - coupling: vertical overlap (crossover) unconditionally -- where one net's conductor on an adjacent metal level sits directly over another *distinct* net's conductor, that overlap area is charged between the two nets instead of to ground (issue #760) -- plus lateral (same-layer, sidewall) coupling, but only for a net pair naming one of the caller's declared `--critical-net` nets (issue #976): facing-edge length within that layer's own minimum-spacing lookback is charged between the two nets, *additively* (not deducted from either net's substrate fringe term, unlike the vertical case -- a known simplification). Any same-layer pair with neither side named `--critical-net`, and fringe shielding in general, are still not modelled
* - resistance: single lumped series resistance per net, distributed as a star across that net's device terminals (issue #592) -- not a per-segment, distributed RC ladder, *unless* `--distributed-rc` names this net via `--critical-net` (issue #977, Epic #709 Phase 2b): then the net's terminals are ordered along their approximate physical spread and its total R/C is broken into a chain of per-segment resistors (segment length proportional to inter-terminal distance) with a ground capacitor at each terminal node (proportional to its adjacent segment length/2), instead of one star hub -- still an approximation (terminal position is a device-placement proxy, not true per-segment routing geometry), but a strictly finer-grained one than the single-hub star
* - frequency: quasi-static -- one frequency-independent R and C per net; no skin effect, no distributed transmission-line behavior
* - substrate tie: 1e+12 ohm to ground -- the substrate is capacitively floating in transient analysis (DC reference only); see --substrate-tie-ohms
.GLOBAL vsubs

* cell bias_core
* pin BIAS_OK,bias_ok
* pin IBIAS,ibias
* pin VDD,vdd
* pin VREF,vref
* pin VSS,vss
.SUBCKT bias_core VDD VSS IBIAS VREF BIAS_OK
* device instance $1 r0 *1 26.42,101 nfet
X$1 nbg__t0 nbg__t1 VSS__t32 VSS__t14 sky130_fd_pr__nfet_g5v0d10v5 L=4 W=2
+ AS=0.84 AD=0.84 PS=4.84 PD=4.84
* device instance $2 r0 *1 33.42,101 nfet
X$2 pb__t8 nbg__t3 VSS__t54 VSS__t15 sky130_fd_pr__nfet_g5v0d10v5 L=4 W=2
+ AS=0.84 AD=0.84 PS=4.84 PD=4.84
* device instance $3 r0 *1 5498.92,101 nfet
X$3 noko__t0 nkg__t1 VSS__t38 VSS__t17 sky130_fd_pr__nfet_g5v0d10v5 L=1 W=2
+ AS=0.84 AD=0.84 PS=4.84 PD=4.84
* device instance $4 r0 *1 72.42,102 nfet
X$4 n1__t0 n1__t1 VSS__t34 VSS__t18 sky130_fd_pr__nfet_g5v0d10v5 L=8 W=4
+ AS=1.68 AD=1.68 PS=8.84 PD=8.84
* device instance $5 r0 *1 83.42,102 nfet
X$5 n2__t3 n1__t3 VSS__t52 VSS__t19 sky130_fd_pr__nfet_g5v0d10v5 L=8 W=4
+ AS=1.68 AD=1.68 PS=8.84 PD=8.84
* device instance $6 r0 *1 5466.42,102 nfet
X$6 nokl__t0 nokl__t1 VSS__t37 VSS__t20 sky130_fd_pr__nfet_g5v0d10v5 L=16
+ W=4 AS=1.68 AD=1.68 PS=8.84 PD=8.84
* device instance $7 r0 *1 5486.42,102 nfet
X$7 noko__t2 nokl__t3 VSS__t41 VSS__t21 sky130_fd_pr__nfet_g5v0d10v5 L=16
+ W=4 AS=1.68 AD=1.68 PS=8.84 PD=8.84
* device instance $8 r0 *1 5525.67,102 nfet
X$8 BIAS_OK__t0 nokx__t1 VSS__t39 VSS__t22
+ sky130_fd_pr__nfet_g5v0d10v5 L=0.5 W=4 AS=1.68 AD=1.68 PS=8.84 PD=8.84
* device instance $9 r0 *1 1346.58,104 nfet
X$9 VSS__t40 nkg__t2 pg__t4 VSS__t23 sky130_fd_pr__nfet_g5v0d10v5 L=4 W=1
+ AS=0.42 AD=0.42 PS=2.84 PD=2.84
* device instance $10 r0 *1 1360.26,104 nfet
X$10 ks4__t0 ks4__t1 nkg__t3 VSS__t24 sky130_fd_pr__nfet_g5v0d10v5 L=8 W=1
+ AS=0.42 AD=0.42 PS=2.84 PD=2.84
* device instance $11 r0 *1 1370.1,104 nfet
X$11 ks3__t1 ks3__t0 ks4__t2 VSS__t25 sky130_fd_pr__nfet_g5v0d10v5 L=8 W=1
+ AS=0.42 AD=0.42 PS=2.84 PD=2.84
* device instance $12 r0 *1 1379.94,104 nfet
X$12 ks2__t1 ks2__t0 ks3__t2 VSS__t26 sky130_fd_pr__nfet_g5v0d10v5 L=8 W=1
+ AS=0.42 AD=0.42 PS=2.84 PD=2.84
* device instance $13 r0 *1 1389.78,104 nfet
X$13 ks1__t1 ks1__t0 ks2__t2 VSS__t27 sky130_fd_pr__nfet_g5v0d10v5 L=8 W=1
+ AS=0.42 AD=0.42 PS=2.84 PD=2.84
* device instance $14 r0 *1 1399.62,104 nfet
X$14 VDD__t15 VDD__t14 ks1__t2 VSS__t28 sky130_fd_pr__nfet_g5v0d10v5 L=8
+ W=1 AS=0.42 AD=0.42 PS=2.84 PD=2.84
* device instance $15 r0 *1 1333.42,104 nfet
X$15 VSS__t53 nkm__t2 nkm__t3 VSS__t16 sky130_fd_pr__nfet_g5v0d10v5 L=4 W=2
+ AS=0.84 AD=0.84 PS=4.84 PD=4.84
* device instance $16 r0 *1 42.42,104 nfet
X$16 pg__t1 n2__t1 VSS__t33 VSS__t29 sky130_fd_pr__nfet_g5v0d10v5 L=8 W=8
+ AS=3.36 AD=3.36 PS=16.84 PD=16.84
* device instance $17 r0 *1 1352.42,104 nfet
X$17 nkg__t0 nkm__t0 VSS__t36 VSS__t30 sky130_fd_pr__nfet_g5v0d10v5 L=4 W=8
+ AS=3.36 AD=3.36 PS=16.84 PD=16.84
* device instance $18 r0 *1 5505.42,104 nfet
X$18 nokx__t5 noko__t3 VSS__t42 VSS__t31 sky130_fd_pr__nfet_g5v0d10v5 L=4
+ W=8 AS=3.36 AD=3.36 PS=16.84 PD=16.84
* device instance $19 r0 *1 1325.42,104 pfet
X$19 nkm__t1 pb__t2 VDD__t8 VDD__t9 sky130_fd_pr__pfet_g5v0d10v5 L=4 W=1
+ AS=0.42 AD=0.42 PS=2.84 PD=2.84
* device instance $20 r0 *1 5506.42,123.22 pfet
X$20 nokx__t2 pb__t3 VDD__t11 VDD__t12 sky130_fd_pr__pfet_g5v0d10v5 L=4
+ W=0.5 AS=0.21 AD=0.21 PS=1.84 PD=1.84
* device instance $21 r0 *1 5452.42,123.47 pfet
X$21 tok__t2 pb__t4 VDD__t19 VDD__t17 sky130_fd_pr__pfet_g5v0d10v5 L=4 W=1
+ AS=0.42 AD=0.42 PS=2.84 PD=2.84
* device instance $22 r0 *1 5527.42,123.47 pfet
X$22 BIAS_OK__t1 nokx__t3 VDD__t18 VDD__t16
+ sky130_fd_pr__pfet_g5v0d10v5 L=4 W=1 AS=0.42 AD=0.42 PS=2.84 PD=2.84
* device instance $23 r0 *1 29.42,123.97 pfet
X$23 nbg__t2 pg__t5 VDD__t3 VDD__t4 sky130_fd_pr__pfet_g5v0d10v5 L=4 W=2
+ AS=0.84 AD=0.84 PS=4.84 PD=4.84
* device instance $24 r0 *1 38.42,123.97 pfet
X$24 pg__t3 pb__t0 VDD__t26 VDD__t22 sky130_fd_pr__pfet_g5v0d10v5 L=4 W=2
+ AS=0.84 AD=0.84 PS=4.84 PD=4.84
* device instance $25 r0 *1 47.42,123.97 pfet
X$25 pb__t5 pb__t6 VDD__t25 VDD__t21 sky130_fd_pr__pfet_g5v0d10v5 L=4 W=2
+ AS=0.84 AD=0.84 PS=4.84 PD=4.84
* device instance $26 r0 *1 65.42,123.97 pfet
X$26 nt__t2 pb__t7 VDD__t27 VDD__t23 sky130_fd_pr__pfet_g5v0d10v5 L=4 W=2
+ AS=0.84 AD=0.84 PS=4.84 PD=4.84
* device instance $27 r0 *1 5517.58,123.97 pfet
X$27 VDD__t28 BIAS_OK__t2 nokx__t4 VDD__t24
+ sky130_fd_pr__pfet_g5v0d10v5 L=4 W=2 AS=0.84 AD=0.84 PS=4.84 PD=4.84
* device instance $28 r0 *1 2.42,126.97 pfet
X$28 nbtop__t1 pg__t2 VDD__t1 VDD__t2 sky130_fd_pr__pfet_g5v0d10v5 L=4 W=8
+ AS=3.36 AD=3.36 PS=16.84 PD=16.84
* device instance $29 r0 *1 11.42,126.97 pfet
X$29 VREF__t1 pg__t7 VDD__t32 VDD__t30 sky130_fd_pr__pfet_g5v0d10v5 L=4
+ W=8 AS=3.36 AD=3.36 PS=16.84 PD=16.84
* device instance $30 r0 *1 20.42,126.97 pfet
X$30 na__t3 pg__t6 VDD__t31 VDD__t29 sky130_fd_pr__pfet_g5v0d10v5 L=4 W=8
+ AS=3.36 AD=3.36 PS=16.84 PD=16.84
* device instance $31 r0 *1 74.42,130.97 pfet
X$31 n1__t2 na__t1 nt__t0 VDD__t7 sky130_fd_pr__pfet_g5v0d10v5 L=4 W=16 AS=6.72
+ AD=6.72 PS=32.84 PD=32.84
* device instance $32 r0 *1 83.42,130.97 pfet
X$32 n2__t2 nb__t1 nt__t1 VDD__t20 sky130_fd_pr__pfet_g5v0d10v5 L=4 W=16 AS=6.72
+ AD=6.72 PS=32.84 PD=32.84
* device instance $33 r0 *1 5463.42,130.97 pfet
X$33 nokl__t2 nbtop__t2 tok__t0 VDD__t10 sky130_fd_pr__pfet_g5v0d10v5 L=8 W=16
+ AS=6.72 AD=6.72 PS=32.84 PD=32.84
* device instance $34 r0 *1 5495.58,130.97 pfet
X$34 tok__t1 na__t2 noko__t1 VDD__t13 sky130_fd_pr__pfet_g5v0d10v5 L=8 W=16
+ AS=6.72 AD=6.72 PS=32.84 PD=32.84
* device instance $35 r0 *1 56.42,142.97 pfet
X$35 IBIAS__t0 pb__t1 VDD__t5 VDD__t6 sky130_fd_pr__pfet_g5v0d10v5 L=4
+ W=40 AS=16.8 AD=16.8 PS=80.84 PD=80.84
* device instance $36 r0 *1 151.7,101.7 pnp
X$36 VSS__t0 VSS__t35 na__t0 sky130_fd_pr__pnp_05v5_W3p40L3p40
* device instance $37 r0 *1 156.32,101.7 pnp
X$37 VSS__t1 VSS__t43 er__t1 sky130_fd_pr__pnp_05v5_W3p40L3p40
* device instance $38 r0 *1 201.7,101.7 pnp
X$38 VSS__t2 VSS__t51 ec__t7 sky130_fd_pr__pnp_05v5_W3p40L3p40
* device instance $39 r0 *1 206.32,101.7 pnp
X$39 VSS__t3 VSS__t44 ec__t0 sky130_fd_pr__pnp_05v5_W3p40L3p40
* device instance $40 r0 *1 210.94,101.7 pnp
X$40 VSS__t4 VSS__t45 ec__t1 sky130_fd_pr__pnp_05v5_W3p40L3p40
* device instance $41 r0 *1 215.56,101.7 pnp
X$41 VSS__t5 VSS__t46 ec__t2 sky130_fd_pr__pnp_05v5_W3p40L3p40
* device instance $42 r0 *1 201.7,105.5 pnp
X$42 VSS__t6 VSS__t47 ec__t3 sky130_fd_pr__pnp_05v5_W3p40L3p40
* device instance $43 r0 *1 206.32,105.5 pnp
X$43 VSS__t7 VSS__t48 ec__t4 sky130_fd_pr__pnp_05v5_W3p40L3p40
* device instance $44 r0 *1 210.94,105.5 pnp
X$44 VSS__t8 VSS__t49 ec__t5 sky130_fd_pr__pnp_05v5_W3p40L3p40
* device instance $45 r0 *1 215.56,105.5 pnp
X$45 VSS__t9 VSS__t50 ec__t6 sky130_fd_pr__pnp_05v5_W3p40L3p40
* device instance $46 r0 *1 5531.87,-46.5 sky130_fd_pr__model__cap_mim
X$46 VDD__t0 nokx__t0 sky130_fd_pr__cap_mim_m3_1 l=6 w=6
* device instance $47 r0 *1 1406.59,-39.5 sky130_fd_pr__model__cap_mim
X$47 nz__t1 pg__t0 sky130_fd_pr__cap_mim_m3_1 l=20 w=20
* device instance $48 r0 *1 -157.11,-49 res_xhigh_po
X$48 nbtop__t0 nb__t0 VSS__t10 sky130_fd_pr__res_xhigh_po l=350 w=2
* device instance $49 r0 *1 197.17,-49 res_xhigh_po
X$49 nb__t2 ec__t8 VSS__t11 sky130_fd_pr__res_xhigh_po l=350 w=2
* device instance $50 r0 *1 884.45,-49 res_xhigh_po
X$50 n2__t0 nz__t0 VSS__t12 sky130_fd_pr__res_xhigh_po l=1016 w=2
* device instance $51 r0 *1 3472.73,-49 res_xhigh_po
X$51 VREF__t0 er__t0 VSS__t13 sky130_fd_pr__res_xhigh_po l=4104 w=2
* device instance BIAS_OK_bias_ok_t0 r0 *1 0,0
RBIAS_OK_bias_ok_t0 BIAS_OK__t0 BIAS_OK 6346.16465394
* device instance BIAS_OK_bias_ok_t1 r0 *1 0,0
RBIAS_OK_bias_ok_t1 BIAS_OK__t1 BIAS_OK 3463.59177762
* device instance BIAS_OK_bias_ok_t2 r0 *1 0,0
RBIAS_OK_bias_ok_t2 BIAS_OK__t2 BIAS_OK 4155.62236843
* device instance BIAS_OK_bias_ok r0 *1 0,0
CBIAS_OK_bias_ok BIAS_OK vsubs 1.7336014e-14
* device instance IBIAS_ibias_t0 r0 *1 0,0
RIBIAS_ibias_t0 IBIAS__t0 IBIAS 1219.0476
* device instance IBIAS_ibias r0 *1 0,0
CIBIAS_ibias IBIAS vsubs 3.911788e-15
* device instance VDD_vdd_t0 r0 *1 0,0
RVDD_vdd_t0 VDD__t0 VDD 18374.4363815
* device instance VDD_vdd_t1 r0 *1 0,0
RVDD_vdd_t1 VDD__t1 VDD 10541.8850637
* device instance VDD_vdd_t2 r0 *1 0,0
RVDD_vdd_t2 VDD__t2 VDD 10541.8850637
* device instance VDD_vdd_t3 r0 *1 0,0
RVDD_vdd_t3 VDD__t3 VDD 10400.7367176
* device instance VDD_vdd_t4 r0 *1 0,0
RVDD_vdd_t4 VDD__t4 VDD 10400.7367176
* device instance VDD_vdd_t5 r0 *1 0,0
RVDD_vdd_t5 VDD__t5 VDD 10260.3807766
* device instance VDD_vdd_t6 r0 *1 0,0
RVDD_vdd_t6 VDD__t6 VDD 10260.3807766
* device instance VDD_vdd_t7 r0 *1 0,0
RVDD_vdd_t7 VDD__t7 VDD 10165.7382048
* device instance VDD_vdd_t8 r0 *1 0,0
RVDD_vdd_t8 VDD__t8 VDD 3628.8654169
* device instance VDD_vdd_t9 r0 *1 0,0
RVDD_vdd_t9 VDD__t9 VDD 3628.8654169
* device instance VDD_vdd_t10 r0 *1 0,0
RVDD_vdd_t10 VDD__t10 VDD 17996.5186632
* device instance VDD_vdd_t11 r0 *1 0,0
RVDD_vdd_t11 VDD__t11 VDD 18221.1314823
* device instance VDD_vdd_t12 r0 *1 0,0
RVDD_vdd_t12 VDD__t12 VDD 18221.1314823
* device instance VDD_vdd_t13 r0 *1 0,0
RVDD_vdd_t13 VDD__t13 VDD 18164.580015
* device instance VDD_vdd_t14 r0 *1 0,0
RVDD_vdd_t14 VDD__t14 VDD 3241.20845633
* device instance VDD_vdd_t15 r0 *1 0,0
RVDD_vdd_t15 VDD__t15 VDD 3241.20845633
* device instance VDD_vdd_t16 r0 *1 0,0
RVDD_vdd_t16 VDD__t16 VDD 18330.8753104
* device instance VDD_vdd_t17 r0 *1 0,0
RVDD_vdd_t17 VDD__t17 VDD 17938.9391236
* device instance VDD_vdd_t18 r0 *1 0,0
RVDD_vdd_t18 VDD__t18 VDD 18330.8753104
* device instance VDD_vdd_t19 r0 *1 0,0
RVDD_vdd_t19 VDD__t19 VDD 17938.9391236
* device instance VDD_vdd_t20 r0 *1 0,0
RVDD_vdd_t20 VDD__t20 VDD 10118.7067414
* device instance VDD_vdd_t21 r0 *1 0,0
RVDD_vdd_t21 VDD__t21 VDD 10306.6722658
* device instance VDD_vdd_t22 r0 *1 0,0
RVDD_vdd_t22 VDD__t22 VDD 10353.704491
* device instance VDD_vdd_t23 r0 *1 0,0
RVDD_vdd_t23 VDD__t23 VDD 10212.6078199
* device instance VDD_vdd_t24 r0 *1 0,0
RVDD_vdd_t24 VDD__t24 VDD 18279.4569399
* device instance VDD_vdd_t25 r0 *1 0,0
RVDD_vdd_t25 VDD__t25 VDD 10306.6722658
* device instance VDD_vdd_t26 r0 *1 0,0
RVDD_vdd_t26 VDD__t26 VDD 10353.704491
* device instance VDD_vdd_t27 r0 *1 0,0
RVDD_vdd_t27 VDD__t27 VDD 10212.6078199
* device instance VDD_vdd_t28 r0 *1 0,0
RVDD_vdd_t28 VDD__t28 VDD 18279.4569399
* device instance VDD_vdd_t29 r0 *1 0,0
RVDD_vdd_t29 VDD__t29 VDD 10447.8210686
* device instance VDD_vdd_t30 r0 *1 0,0
RVDD_vdd_t30 VDD__t30 VDD 10494.8530644
* device instance VDD_vdd_t31 r0 *1 0,0
RVDD_vdd_t31 VDD__t31 VDD 10447.8210686
* device instance VDD_vdd_t32 r0 *1 0,0
RVDD_vdd_t32 VDD__t32 VDD 10494.8530644
* device instance VDD_vdd r0 *1 0,0
CVDD_vdd VDD vsubs 6.72600478e-13
* device instance VREF_vref_t0 r0 *1 0,0
RVREF_vref_t0 VREF__t0 VREF 256.40605
* device instance VREF_vref_t1 r0 *1 0,0
RVREF_vref_t1 VREF__t1 VREF 256.40605
* device instance VREF_vref r0 *1 0,0
CVREF_vref VREF vsubs 1.39993165e-13
* device instance VSS_vss_t0 r0 *1 0,0
RVSS_vss_t0 VSS__t0 VSS 239.333414652
* device instance VSS_vss_t1 r0 *1 0,0
RVSS_vss_t1 VSS__t1 VSS 238.470287011
* device instance VSS_vss_t2 r0 *1 0,0
RVSS_vss_t2 VSS__t2 VSS 229.992216533
* device instance VSS_vss_t3 r0 *1 0,0
RVSS_vss_t3 VSS__t3 VSS 229.129090998
* device instance VSS_vss_t4 r0 *1 0,0
RVSS_vss_t4 VSS__t4 VSS 228.265965671
* device instance VSS_vss_t5 r0 *1 0,0
RVSS_vss_t5 VSS__t5 VSS 227.402840553
* device instance VSS_vss_t6 r0 *1 0,0
RVSS_vss_t6 VSS__t6 VSS 229.998965061
* device instance VSS_vss_t7 r0 *1 0,0
RVSS_vss_t7 VSS__t7 VSS 229.135864947
* device instance VSS_vss_t8 r0 *1 0,0
RVSS_vss_t8 VSS__t8 VSS 228.272765232
* device instance VSS_vss_t9 r0 *1 0,0
RVSS_vss_t9 VSS__t9 VSS 227.409665922
* device instance VSS_vss_t10 r0 *1 0,0
RVSS_vss_t10 VSS__t10 VSS 298.185492484
* device instance VSS_vss_t11 r0 *1 0,0
RVSS_vss_t11 VSS__t11 VSS 232.327405426
* device instance VSS_vss_t12 r0 *1 0,0
RVSS_vss_t12 VSS__t12 VSS 105.75555296
* device instance VSS_vss_t13 r0 *1 0,0
RVSS_vss_t13 VSS__t13 VSS 382.048443794
* device instance VSS_vss_t14 r0 *1 0,0
RVSS_vss_t14 VSS__t14 VSS 262.737930542
* device instance VSS_vss_t15 r0 *1 0,0
RVSS_vss_t15 VSS__t15 VSS 261.430150495
* device instance VSS_vss_t16 r0 *1 0,0
RVSS_vss_t16 VSS__t16 VSS 18.6833814681
* device instance VSS_vss_t17 r0 *1 0,0
RVSS_vss_t17 VSS__t17 VSS 759.694755379
* device instance VSS_vss_t18 r0 *1 0,0
RVSS_vss_t18 VSS__t18 VSS 254.145271318
* device instance VSS_vss_t19 r0 *1 0,0
RVSS_vss_t19 VSS__t19 VSS 252.090202258
* device instance VSS_vss_t20 r0 *1 0,0
RVSS_vss_t20 VSS__t20 VSS 753.623251693
* device instance VSS_vss_t21 r0 *1 0,0
RVSS_vss_t21 VSS__t21 VSS 757.359833107
* device instance VSS_vss_t22 r0 *1 0,0
RVSS_vss_t22 VSS__t22 VSS 764.692874463
* device instance VSS_vss_t23 r0 *1 0,0
RVSS_vss_t23 VSS__t23 VSS 16.2454979392
* device instance VSS_vss_t24 r0 *1 0,0
RVSS_vss_t24 VSS__t24 VSS 13.7191545484
* device instance VSS_vss_t25 r0 *1 0,0
RVSS_vss_t25 VSS__t25 VSS 11.9097430369
* device instance VSS_vss_t26 r0 *1 0,0
RVSS_vss_t26 VSS__t26 VSS 10.1107968971
* device instance VSS_vss_t27 r0 *1 0,0
RVSS_vss_t27 VSS__t27 VSS 8.32909992672
* device instance VSS_vss_t28 r0 *1 0,0
RVSS_vss_t28 VSS__t28 VSS 6.57868180493
* device instance VSS_vss_t29 r0 *1 0,0
RVSS_vss_t29 VSS__t29 VSS 259.75299343
* device instance VSS_vss_t30 r0 *1 0,0
RVSS_vss_t30 VSS__t30 VSS 15.1657917818
* device instance VSS_vss_t31 r0 *1 0,0
RVSS_vss_t31 VSS__t31 VSS 760.910604106
* device instance VSS_vss_t32 r0 *1 0,0
RVSS_vss_t32 VSS__t32 VSS 262.737930542
* device instance VSS_vss_t33 r0 *1 0,0
RVSS_vss_t33 VSS__t33 VSS 259.75299343
* device instance VSS_vss_t34 r0 *1 0,0
RVSS_vss_t34 VSS__t34 VSS 254.145271318
* device instance VSS_vss_t35 r0 *1 0,0
RVSS_vss_t35 VSS__t35 VSS 239.333414652
* device instance VSS_vss_t36 r0 *1 0,0
RVSS_vss_t36 VSS__t36 VSS 15.1657917818
* device instance VSS_vss_t37 r0 *1 0,0
RVSS_vss_t37 VSS__t37 VSS 753.623251693
* device instance VSS_vss_t38 r0 *1 0,0
RVSS_vss_t38 VSS__t38 VSS 759.694755379
* device instance VSS_vss_t39 r0 *1 0,0
RVSS_vss_t39 VSS__t39 VSS 764.692874463
* device instance VSS_vss_t40 r0 *1 0,0
RVSS_vss_t40 VSS__t40 VSS 16.2454979392
* device instance VSS_vss_t41 r0 *1 0,0
RVSS_vss_t41 VSS__t41 VSS 757.359833107
* device instance VSS_vss_t42 r0 *1 0,0
RVSS_vss_t42 VSS__t42 VSS 760.910604106
* device instance VSS_vss_t43 r0 *1 0,0
RVSS_vss_t43 VSS__t43 VSS 238.470287011
* device instance VSS_vss_t44 r0 *1 0,0
RVSS_vss_t44 VSS__t44 VSS 229.129090998
* device instance VSS_vss_t45 r0 *1 0,0
RVSS_vss_t45 VSS__t45 VSS 228.265965671
* device instance VSS_vss_t46 r0 *1 0,0
RVSS_vss_t46 VSS__t46 VSS 227.402840553
* device instance VSS_vss_t47 r0 *1 0,0
RVSS_vss_t47 VSS__t47 VSS 229.998965061
* device instance VSS_vss_t48 r0 *1 0,0
RVSS_vss_t48 VSS__t48 VSS 229.135864947
* device instance VSS_vss_t49 r0 *1 0,0
RVSS_vss_t49 VSS__t49 VSS 228.272765232
* device instance VSS_vss_t50 r0 *1 0,0
RVSS_vss_t50 VSS__t50 VSS 227.409665922
* device instance VSS_vss_t51 r0 *1 0,0
RVSS_vss_t51 VSS__t51 VSS 229.992216533
* device instance VSS_vss_t52 r0 *1 0,0
RVSS_vss_t52 VSS__t52 VSS 252.090202258
* device instance VSS_vss_t53 r0 *1 0,0
RVSS_vss_t53 VSS__t53 VSS 18.6833814681
* device instance VSS_vss_t54 r0 *1 0,0
RVSS_vss_t54 VSS__t54 VSS 261.430150495
* device instance VSS_vss r0 *1 0,0
CVSS_vss VSS vsubs 5.59923546e-13
* device instance ec_t0 r0 *1 0,0
Rec_t0 ec__t0 ec 32.6065357598
* device instance ec_t1 r0 *1 0,0
Rec_t1 ec__t1 ec 33.4381799519
* device instance ec_t2 r0 *1 0,0
Rec_t2 ec__t2 ec 37.0448780712
* device instance ec_t3 r0 *1 0,0
Rec_t3 ec__t3 ec 42.5337191546
* device instance ec_t4 r0 *1 0,0
Rec_t4 ec__t4 ec 40.8014406705
* device instance ec_t5 r0 *1 0,0
Rec_t5 ec__t5 ec 41.4690639517
* device instance ec_t6 r0 *1 0,0
Rec_t6 ec__t6 ec 44.4285311241
* device instance ec_t7 r0 *1 0,0
Rec_t7 ec__t7 ec 34.7497608422
* device instance ec_t8 r0 *1 0,0
Rec_t8 ec__t8 ec 293.902990474
* device instance ec r0 *1 0,0
Cec ec vsubs 4.2960383e-14
* device instance er_t0 r0 *1 0,0
Rer_t0 er__t0 er 373.5572
* device instance er_t1 r0 *1 0,0
Rer_t1 er__t1 er 373.5572
* device instance er r0 *1 0,0
Cer er vsubs 4.84395273e-13
* device instance ks1_t0 r0 *1 0,0
Rks1_t0 ks1__t0 ks1 1377.612675
* device instance ks1_t1 r0 *1 0,0
Rks1_t1 ks1__t1 ks1 1377.612675
* device instance ks1_t2 r0 *1 0,0
Rks1_t2 ks1__t2 ks1 2755.22535
* device instance ks1 r0 *1 0,0
Cks1 ks1 vsubs 3.026103e-15
* device instance ks2_t0 r0 *1 0,0
Rks2_t0 ks2__t0 ks2 1377.612675
* device instance ks2_t1 r0 *1 0,0
Rks2_t1 ks2__t1 ks2 1377.612675
* device instance ks2_t2 r0 *1 0,0
Rks2_t2 ks2__t2 ks2 2755.22535
* device instance ks2 r0 *1 0,0
Cks2 ks2 vsubs 3.026103e-15
* device instance ks3_t0 r0 *1 0,0
Rks3_t0 ks3__t0 ks3 1377.612675
* device instance ks3_t1 r0 *1 0,0
Rks3_t1 ks3__t1 ks3 1377.612675
* device instance ks3_t2 r0 *1 0,0
Rks3_t2 ks3__t2 ks3 2755.22535
* device instance ks3 r0 *1 0,0
Cks3 ks3 vsubs 3.026103e-15
* device instance ks4_t0 r0 *1 0,0
Rks4_t0 ks4__t0 ks4 1377.612675
* device instance ks4_t1 r0 *1 0,0
Rks4_t1 ks4__t1 ks4 1377.612675
* device instance ks4_t2 r0 *1 0,0
Rks4_t2 ks4__t2 ks4 2755.22535
* device instance ks4 r0 *1 0,0
Cks4 ks4 vsubs 3.026103e-15
* device instance n1_t0 r0 *1 0,0
Rn1_t0 n1__t0 n1 2337.15353461
* device instance n1_t1 r0 *1 0,0
Rn1_t1 n1__t1 n1 2337.15353461
* device instance n1_t2 r0 *1 0,0
Rn1_t2 n1__t2 n1 6407.49174882
* device instance n1_t3 r0 *1 0,0
Rn1_t3 n1__t3 n1 3122.97498195
* device instance n1 r0 *1 0,0
Cn1 n1 vsubs 1.1326286e-14
* device instance n2_t0 r0 *1 0,0
Rn2_t0 n2__t0 n2 2991.79205262
* device instance n2_t1 r0 *1 0,0
Rn2_t1 n2__t1 n2 1120.15405141
* device instance n2_t2 r0 *1 0,0
Rn2_t2 n2__t2 n2 955.579645052
* device instance n2_t3 r0 *1 0,0
Rn2_t3 n2__t3 n2 923.937650916
* device instance n2 r0 *1 0,0
Cn2 n2 vsubs 6.460138e-14
* device instance na_t0 r0 *1 0,0
Rna_t0 na__t0 na 1373.12285394
* device instance na_t1 r0 *1 0,0
Rna_t1 na__t1 na 1455.61116787
* device instance na_t2 r0 *1 0,0
Rna_t2 na__t2 na 4341.86522986
* device instance na_t3 r0 *1 0,0
Rna_t3 na__t3 na 1513.33914834
* device instance na r0 *1 0,0
Cna na vsubs 4.61872849e-13
* device instance nb_t0 r0 *1 0,0
Rnb_t0 nb__t0 nb 1195.06561074
* device instance nb_t1 r0 *1 0,0
Rnb_t1 nb__t1 nb 733.86752173
* device instance nb_t2 r0 *1 0,0
Rnb_t2 nb__t2 nb 964.29646753
* device instance nb r0 *1 0,0
Cnb nb vsubs 2.8787383e-14
* device instance nbg_t0 r0 *1 0,0
Rnbg_t0 nbg__t0 nbg 1316.15971154
* device instance nbg_t1 r0 *1 0,0
Rnbg_t1 nbg__t1 nbg 1316.15971154
* device instance nbg_t2 r0 *1 0,0
Rnbg_t2 nbg__t2 nbg 3621.80431749
* device instance nbg_t3 r0 *1 0,0
Rnbg_t3 nbg__t3 nbg 1533.14435943
* device instance nbg r0 *1 0,0
Cnbg nbg vsubs 6.240576e-15
* device instance nbtop_t0 r0 *1 0,0
Rnbtop_t0 nbtop__t0 nbtop 1575.22660873
* device instance nbtop_t1 r0 *1 0,0
Rnbtop_t1 nbtop__t1 nbtop 1442.82436186
* device instance nbtop_t2 r0 *1 0,0
Rnbtop_t2 nbtop__t2 nbtop 3014.72952941
* device instance nbtop r0 *1 0,0
Cnbtop nbtop vsubs 5.28928494e-13
* device instance nkg_t0 r0 *1 0,0
Rnkg_t0 nkg__t0 nkg 1360.19755476
* device instance nkg_t1 r0 *1 0,0
Rnkg_t1 nkg__t1 nkg 4077.96964998
* device instance nkg_t2 r0 *1 0,0
Rnkg_t2 nkg__t2 nkg 1367.85675647
* device instance nkg_t3 r0 *1 0,0
Rnkg_t3 nkg__t3 nkg 1349.91533879
* device instance nkg r0 *1 0,0
Cnkg nkg vsubs 3.52073999e-13
* device instance nkm_t0 r0 *1 0,0
Rnkm_t0 nkm__t0 nkm 2517.53325
* device instance nkm_t1 r0 *1 0,0
Rnkm_t1 nkm__t1 nkm 1665.44507308
* device instance nkm_t2 r0 *1 0,0
Rnkm_t2 nkm__t2 nkm 426.044088462
* device instance nkm_t3 r0 *1 0,0
Rnkm_t3 nkm__t3 nkm 426.044088462
* device instance nkm r0 *1 0,0
Cnkm nkm vsubs 5.650455e-15
* device instance nokl_t0 r0 *1 0,0
Rnokl_t0 nokl__t0 nokl 3582.01807122
* device instance nokl_t1 r0 *1 0,0
Rnokl_t1 nokl__t1 nokl 3582.01807122
* device instance nokl_t2 r0 *1 0,0
Rnokl_t2 nokl__t2 nokl 9770.49329317
* device instance nokl_t3 r0 *1 0,0
Rnokl_t3 nokl__t3 nokl 7394.63966439
* device instance nokl r0 *1 0,0
Cnokl nokl vsubs 1.5307121e-14
* device instance noko_t0 r0 *1 0,0
Rnoko_t0 noko__t0 noko 1138.19939542
* device instance noko_t1 r0 *1 0,0
Rnoko_t1 noko__t1 noko 2778.5405815
* device instance noko_t2 r0 *1 0,0
Rnoko_t2 noko__t2 noko 1631.88842324
* device instance noko_t3 r0 *1 0,0
Rnoko_t3 noko__t3 noko 1344.37809983
* device instance noko r0 *1 0,0
Cnoko noko vsubs 8.592042e-15
* device instance nokx_t0 r0 *1 0,0
Rnokx_t0 nokx__t0 nokx 3704.20526674
* device instance nokx_t1 r0 *1 0,0
Rnokx_t1 nokx__t1 nokx 414.420015651
* device instance nokx_t2 r0 *1 0,0
Rnokx_t2 nokx__t2 nokx 1013.97069797
* device instance nokx_t3 r0 *1 0,0
Rnokx_t3 nokx__t3 nokx 986.8678097
* device instance nokx_t4 r0 *1 0,0
Rnokx_t4 nokx__t4 nokx 974.565154677
* device instance nokx_t5 r0 *1 0,0
Rnokx_t5 nokx__t5 nokx 567.512155271
* device instance nokx r0 *1 0,0
Cnokx nokx vsubs 3.3766429e-14
* device instance nt_t0 r0 *1 0,0
Rnt_t0 nt__t0 nt 356.693856449
* device instance nt_t1 r0 *1 0,0
Rnt_t1 nt__t1 nt 1421.30534013
* device instance nt_t2 r0 *1 0,0
Rnt_t2 nt__t2 nt 1549.77430342
* device instance nt r0 *1 0,0
Cnt nt vsubs 6.783752e-15
* device instance nz_t0 r0 *1 0,0
Rnz_t0 nz__t0 nz 496.153
* device instance nz_t1 r0 *1 0,0
Rnz_t1 nz__t1 nz 496.153
* device instance nz r0 *1 0,0
Cnz nz vsubs 1.0837905e-14
* device instance pb_t0 r0 *1 0,0
Rpb_t0 pb__t0 pb 1485.01245195
* device instance pb_t1 r0 *1 0,0
Rpb_t1 pb__t1 pb 1465.52758961
* device instance pb_t2 r0 *1 0,0
Rpb_t2 pb__t2 pb 80.4364304088
* device instance pb_t3 r0 *1 0,0
Rpb_t3 pb__t3 pb 4491.95025795
* device instance pb_t4 r0 *1 0,0
Rpb_t4 pb__t4 pb 4432.92411597
* device instance pb_t5 r0 *1 0,0
Rpb_t5 pb__t5 pb 1475.17475698
* device instance pb_t6 r0 *1 0,0
Rpb_t6 pb__t6 pb 1475.17475698
* device instance pb_t7 r0 *1 0,0
Rpb_t7 pb__t7 pb 1455.4993679
* device instance pb_t8 r0 *1 0,0
Rpb_t8 pb__t8 pb 1490.63777227
* device instance pb r0 *1 0,0
Cpb pb vsubs 5.07894213e-13
* device instance pg_t0 r0 *1 0,0
Rpg_t0 pg__t0 pg 2736.08680072
* device instance pg_t1 r0 *1 0,0
Rpg_t1 pg__t1 pg 830.531714203
* device instance pg_t2 r0 *1 0,0
Rpg_t2 pg__t2 pg 937.016281629
* device instance pg_t3 r0 *1 0,0
Rpg_t3 pg__t3 pg 843.207858364
* device instance pg_t4 r0 *1 0,0
Rpg_t4 pg__t4 pg 2556.30009688
* device instance pg_t5 r0 *1 0,0
Rpg_t5 pg__t5 pg 866.515884629
* device instance pg_t6 r0 *1 0,0
Rpg_t6 pg__t6 pg 890.413682387
* device instance pg_t7 r0 *1 0,0
Rpg_t7 pg__t7 pg 913.713181182
* device instance pg r0 *1 0,0
Cpg pg vsubs 1.36258908e-13
* device instance tok_t0 r0 *1 0,0
Rtok_t0 tok__t0 tok 154.743161183
* device instance tok_t1 r0 *1 0,0
Rtok_t1 tok__t1 tok 521.736066894
* device instance tok_t2 r0 *1 0,0
Rtok_t2 tok__t2 tok 387.369271923
* device instance tok r0 *1 0,0
Ctok tok vsubs 9.785621e-15
* device instance cc_VDD_vdd_VSS_vss r0 *1 0,0
Ccc_VDD_vdd_VSS_vss VDD VSS 3.2616e-17
* device instance cc_VDD_vdd_na r0 *1 0,0
Ccc_VDD_vdd_na VDD na 7.737e-18
* device instance cc_VDD_vdd_nokx r0 *1 0,0
Ccc_VDD_vdd_nokx VDD nokx 1.7646e-17
* device instance cc_VDD_vdd_nt r0 *1 0,0
Ccc_VDD_vdd_nt VDD nt 5.8162e-17
* device instance cc_VDD_vdd_tok r0 *1 0,0
Ccc_VDD_vdd_tok VDD tok 1.4785e-17
* device instance cc_VREF_vref_n2 r0 *1 0,0
Ccc_VREF_vref_n2 VREF n2 5.861e-18
* device instance cc_VREF_vref_na r0 *1 0,0
Ccc_VREF_vref_na VREF na 4.6387e-17
* device instance cc_VREF_vref_nkg r0 *1 0,0
Ccc_VREF_vref_nkg VREF nkg 5.861e-18
* device instance cc_VSS_vss_ec r0 *1 0,0
Ccc_VSS_vss_ec VSS ec 1.80367e-16
* device instance cc_VSS_vss_er r0 *1 0,0
Ccc_VSS_vss_er VSS er 6.6008e-17
* device instance cc_n1_n2 r0 *1 0,0
Ccc_n1_n2 n1 n2 2.16854e-16
* device instance cc_n2_na r0 *1 0,0
Ccc_n2_na n2 na 2.689e-17
* device instance cc_n2_nbtop r0 *1 0,0
Ccc_n2_nbtop n2 nbtop 5.861e-18
* device instance cc_n2_pb r0 *1 0,0
Ccc_n2_pb n2 pb 3.869e-18
* device instance cc_n2_pg r0 *1 0,0
Ccc_n2_pg n2 pg 3.869e-18
* device instance cc_na_nb r0 *1 0,0
Ccc_na_nb na nb 1.7324e-17
* device instance cc_na_nbtop r0 *1 0,0
Ccc_na_nbtop na nbtop 2.3444e-17
* device instance cc_nb_pg r0 *1 0,0
Ccc_nb_pg nb pg 4.6543e-17
* device instance cc_nbg_pb r0 *1 0,0
Ccc_nbg_pb nbg pb 3.3e-18
* device instance cc_nbtop_nkg r0 *1 0,0
Ccc_nbtop_nkg nbtop nkg 1.1722e-17
* device instance cc_nbtop_pb r0 *1 0,0
Ccc_nbtop_pb nbtop pb 6.076e-18
* device instance cc_nkg_nkm r0 *1 0,0
Ccc_nkg_nkm nkg nkm 7.169e-18
* device instance cc_nz_pg r0 *1 0,0
Ccc_nz_pg nz pg 1.7646e-17
* device instance cc_pb_pg r0 *1 0,0
Ccc_pb_pg pb pg 6.6943e-17
* device instance vsubs_dctie r0 *1 0,0
Rvsubs_dctie vsubs 0 1e+12
.ENDS bias_core
