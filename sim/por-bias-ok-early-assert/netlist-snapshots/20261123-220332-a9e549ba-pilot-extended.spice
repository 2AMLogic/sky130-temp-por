* ===== derived netlist, offset device XMOL2 =====
** klt-netlist-inputs: {"pdk_variant": "sky130A", "rcfile": "xschemrc", "xschem_version": "3.4.7"}
** sch_path: sim/por-bias-ok-early-assert/testbench/tb_bias_ok_early_assert.sch
**.subckt tb_bias_ok_early_assert
VSET VSETN 0 3.63
BVDD VDD 0 V = min(v(VSETN), min({rate}*time, max(0, 2*v(VSETN) - {rate}*time))) m=1
XDUT VDD 0 IBIAS VREF BIAS_OK POR_RAW por_comparator
XCHAIN VDD 0 IBIAS POR_RAW RESETn por_output_chain
XBIAS VDD 0 IBIAS VREF BIAS_OK bias_core
**** begin user architecture code

.save v(vdd) v(por_raw) v(resetn) v(vref) v(ibias) v(bias_ok) i(bvdd)
.save v(xdut.sns) v(xdut.snsb) v(xdut.n1) v(xdut.cmpo)
* issue #455: OK-detector internal nodes of the real bias_core, so a failed-release
* realisation can be attributed inside the settle detector (input pair / mirror / output
* stage) from per-sample node levels, not only from BIAS_OK itself
.save v(xbias.na) v(xbias.nbtop) v(xbias.pb) v(xbias.tok) v(xbias.noko) v(xbias.nokl) v(xbias.nokx) v(xbias.nkg)
.options method=gear trtol=50

**** end user architecture code
**.ends

* por_comparator -- generated by design/netlist.py from design/por_comparator.sch
* Do not edit: edit the schematic and re-run the export.
** sch_path: design/por_comparator.sch
.subckt por_comparator VDD VSS IBIAS VREF BIAS_OK POR_RAW
*.PININFO VDD:B VSS:B IBIAS:I VREF:I BIAS_OK:I POR_RAW:O
XMENP BIAS_OKB BIAS_OK VDD VDD sky130_fd_pr__pfet_g5v0d10v5 L=0.5 W=2 nf=1 ad=0.58 as=0.58 pd=4.58 ps=4.58 nrd=0.145 nrs=0.145
+ sa=0 sb=0 sd=0 mult=1 m=1
XMENN BIAS_OKB BIAS_OK VSS VSS sky130_fd_pr__nfet_g5v0d10v5 L=0.5 W=1 nf=1 ad=0.29 as=0.29 pd=2.58 ps=2.58 nrd=0.29 nrs=0.29 sa=0
+ sb=0 sd=0 mult=1 m=1
XMBD IBIAS NBG VSS VSS sky130_fd_pr__nfet_g5v0d10v5 L=2 W=2 nf=1 ad=0.58 as=0.58 pd=4.58 ps=4.58 nrd=0.145 nrs=0.145 sa=0 sb=0
+ sd=0 mult=1 m=1
XMPASS IBIAS BIAS_OK NBG VSS sky130_fd_pr__nfet_g5v0d10v5 L=0.5 W=2 nf=1 ad=0.58 as=0.58 pd=4.58 ps=4.58 nrd=0.145 nrs=0.145 sa=0
+ sb=0 sd=0 mult=1 m=1
XMDNB NBG BIAS_OKB VSS VSS sky130_fd_pr__nfet_g5v0d10v5 L=0.5 W=2 nf=1 ad=0.58 as=0.58 pd=4.58 ps=4.58 nrd=0.145 nrs=0.145 sa=0
+ sb=0 sd=0 mult=1 m=1
XMDIB IBIAS BIAS_OKB VSS VSS sky130_fd_pr__nfet_g5v0d10v5 L=1 W=1 nf=1 ad=0.29 as=0.29 pd=2.58 ps=2.58 nrd=0.29 nrs=0.29 sa=0 sb=0
+ sd=0 mult=1 m=1
XRTOP SNS VDD VSS sky130_fd_pr__res_xhigh_po W=2 L=7897.44 mult=1 m=1
XRBOT SNSB SNS VSS sky130_fd_pr__res_xhigh_po W=2 L=6769.23 mult=1 m=1
XRHYS VSS SNSB VSS sky130_fd_pr__res_xhigh_po W=2 L=775.0 mult=1 m=1
XMHSW SNSB N1 VSS VSS sky130_fd_pr__nfet_g5v0d10v5 L=0.5 W=10 nf=1 ad=2.9 as=2.9 pd=20.58 ps=20.58 nrd=0.029 nrs=0.029 sa=0 sb=0
+ sd=0 mult=1 m=1
XMTAIL TN NBG VSS VSS sky130_fd_pr__nfet_g5v0d10v5 L=10 W=1 nf=1 ad=0.29 as=0.29 pd=2.58 ps=2.58 nrd=0.29 nrs=0.29 sa=0 sb=0 sd=0
+ mult=1 m=1
XMINA NA SNS TN VSS sky130_fd_pr__nfet_g5v0d10v5 L=1 W=2 nf=1 ad=0.58 as=0.58 pd=4.58 ps=4.58 nrd=0.145 nrs=0.145 sa=0 sb=0 sd=0
+ mult=1 m=1
XMINB CMPO VREF TN VSS sky130_fd_pr__nfet_g5v0d10v5 L=1 W=2 nf=1 ad=0.58 as=0.58 pd=4.58 ps=4.58 nrd=0.145 nrs=0.145 sa=0 sb=0
+ sd=0 mult=1 m=1
XMLA NA NA VDDA VDD sky130_fd_pr__pfet_g5v0d10v5 L=1 W=4 nf=1 ad=1.16 as=1.16 pd=8.58 ps=8.58 nrd=0.0725 nrs=0.0725 sa=0 sb=0 sd=0
+ mult=1 m=1
XMLB CMPO NA VDDA VDD sky130_fd_pr__pfet_g5v0d10v5 L=1 W=4 nf=1 ad=1.16 as=1.16 pd=8.58 ps=8.58 nrd=0.0725 nrs=0.0725 sa=0 sb=0
+ sd=0 mult=1 m=1
XMENSRC VDDA BIAS_OKB VDD VDD sky130_fd_pr__pfet_g5v0d10v5 L=0.5 W=4 nf=1 ad=1.16 as=1.16 pd=8.58 ps=8.58 nrd=0.0725 nrs=0.0725
+ sa=0 sb=0 sd=0 mult=1 m=1
XMDCMPO CMPO BIAS_OKB VSS VSS sky130_fd_pr__nfet_g5v0d10v5 L=1 W=2 nf=1 ad=0.58 as=0.58 pd=4.58 ps=4.58 nrd=0.145 nrs=0.145 sa=0
+ sb=0 sd=0 mult=1 m=1
XMI1P N1 CMPO VDD VDD sky130_fd_pr__pfet_g5v0d10v5 L=0.5 W=2 nf=1 ad=0.58 as=0.58 pd=4.58 ps=4.58 nrd=0.145 nrs=0.145 sa=0 sb=0
+ sd=0 mult=1 m=1
XMI1N N1 CMPO VSS VSS sky130_fd_pr__nfet_g5v0d10v5 L=0.5 W=1 nf=1 ad=0.29 as=0.29 pd=2.58 ps=2.58 nrd=0.29 nrs=0.29 sa=0 sb=0 sd=0
+ mult=1 m=1
XMI2P POR_RAW N1 VDD VDD sky130_fd_pr__pfet_g5v0d10v5 L=0.5 W=2 nf=1 ad=0.58 as=0.58 pd=4.58 ps=4.58 nrd=0.145 nrs=0.145 sa=0 sb=0
+ sd=0 mult=1 m=1
XMI2N POR_RAW N1 VSS VSS sky130_fd_pr__nfet_g5v0d10v5 L=0.5 W=1 nf=1 ad=0.29 as=0.29 pd=2.58 ps=2.58 nrd=0.29 nrs=0.29 sa=0 sb=0
+ sd=0 mult=1 m=1
.ends
* por_output_chain -- generated by design/netlist.py from design/por_output_chain.sch
* Do not edit: edit the schematic and re-run the export.
** sch_path: design/por_output_chain.sch
.subckt por_output_chain VDD VSS IBIAS POR_RAW RESETn
*.PININFO VDD:B VSS:B IBIAS:I POR_RAW:I RESETn:O
XMBD IBIAS IBIAS VSS VSS sky130_fd_pr__nfet_g5v0d10v5 L=4 W=4 nf=1 ad=1.16 as=1.16 pd=8.58 ps=8.58 nrd=0.0725 nrs=0.0725 sa=0 sb=0
+ sd=0 mult=1 m=1
XMN1 PDN IBIAS VSS VSS sky130_fd_pr__nfet_g5v0d10v5 L=20 W=0.42 nf=1 ad=0.1218 as=0.1218 pd=1.42 ps=1.42 nrd=0.69047619047619
+ nrs=0.69047619047619 sa=0 sb=0 sd=0 mult=1 m=1
XMPD PDN PDN VDD VDD sky130_fd_pr__pfet_g5v0d10v5 L=10 W=2 nf=1 ad=0.58 as=0.58 pd=4.58 ps=4.58 nrd=0.145 nrs=0.145 sa=0 sb=0 sd=0
+ mult=1 m=1
XMP2 NDL PDN VDD VDD sky130_fd_pr__pfet_g5v0d10v5 L=10 W=2 nf=1 ad=0.58 as=0.58 pd=4.58 ps=4.58 nrd=0.145 nrs=0.145 sa=0 sb=0 sd=0
+ mult=1 m=1
XMND NDL NDL VSS VSS sky130_fd_pr__nfet_g5v0d10v5 L=10 W=2 nf=1 ad=0.58 as=0.58 pd=4.58 ps=4.58 nrd=0.145 nrs=0.145 sa=0 sb=0 sd=0
+ mult=1 m=1
XMDGPT NDGP PDN VDD VDD sky130_fd_pr__pfet_g5v0d10v5 L=10 W=10 nf=1 ad=2.9 as=2.9 pd=20.58 ps=20.58 nrd=0.029 nrs=0.029 sa=0 sb=0
+ sd=0 mult=1 m=1
XMDGPI NDG POR_RAW NDGP VDD sky130_fd_pr__pfet_g5v0d10v5 L=0.5 W=1 nf=1 ad=0.29 as=0.29 pd=2.58 ps=2.58 nrd=0.29 nrs=0.29 sa=0
+ sb=0 sd=0 mult=1 m=1
XMDGNI NDG POR_RAW NDGN VSS sky130_fd_pr__nfet_g5v0d10v5 L=0.5 W=1 nf=1 ad=0.29 as=0.29 pd=2.58 ps=2.58 nrd=0.29 nrs=0.29 sa=0
+ sb=0 sd=0 mult=1 m=1
XMDGNT NDGN NDL VSS VSS sky130_fd_pr__nfet_g5v0d10v5 L=10 W=10 nf=1 ad=2.9 as=2.9 pd=20.58 ps=20.58 nrd=0.029 nrs=0.029 sa=0 sb=0
+ sd=0 mult=1 m=1
XCDG NDG VSS sky130_fd_pr__cap_mim_m3_1 W=11 L=11 MF=1 m=1
XMG1P PGDG NDG VDD VDD sky130_fd_pr__pfet_g5v0d10v5 L=2 W=0.5 nf=1 ad=0.145 as=0.145 pd=1.58 ps=1.58 nrd=0.58 nrs=0.58 sa=0 sb=0
+ sd=0 mult=1 m=1
XMG1N PGDG NDG VSS VSS sky130_fd_pr__nfet_g5v0d10v5 L=0.5 W=2 nf=1 ad=0.58 as=0.58 pd=4.58 ps=4.58 nrd=0.145 nrs=0.145 sa=0 sb=0
+ sd=0 mult=1 m=1
XMG2P PGDGB PGDG VDD VDD sky130_fd_pr__pfet_g5v0d10v5 L=0.5 W=2 nf=1 ad=0.58 as=0.58 pd=4.58 ps=4.58 nrd=0.145 nrs=0.145 sa=0 sb=0
+ sd=0 mult=1 m=1
XMG2N PGDGB PGDG VSS VSS sky130_fd_pr__nfet_g5v0d10v5 L=2 W=0.5 nf=1 ad=0.145 as=0.145 pd=1.58 ps=1.58 nrd=0.58 nrs=0.58 sa=0 sb=0
+ sd=0 mult=1 m=1
XMPT NTS PDN VDD VDD sky130_fd_pr__pfet_g5v0d10v5 L=10 W=0.5 nf=1 ad=0.145 as=0.145 pd=1.58 ps=1.58 nrd=0.58 nrs=0.58 sa=0 sb=0
+ sd=0 mult=1 m=1
XMTSW TIM PGDGB NTS VDD sky130_fd_pr__pfet_g5v0d10v5 L=1 W=2 nf=1 ad=0.58 as=0.58 pd=4.58 ps=4.58 nrd=0.145 nrs=0.145 sa=0 sb=0
+ sd=0 mult=1 m=1
XMDIS TIM PGDGB VSS VSS sky130_fd_pr__nfet_g5v0d10v5 L=1 W=1 nf=1 ad=0.29 as=0.29 pd=2.58 ps=2.58 nrd=0.29 nrs=0.29 sa=0 sb=0 sd=0
+ mult=1 m=1
XCTIM TIM VSS sky130_fd_pr__cap_mim_m3_1 W=28 L=28 MF=4 m=4
XMDAPI ND1 TIM VDD VDD sky130_fd_pr__pfet_g5v0d10v5 L=1 W=2 nf=1 ad=0.58 as=0.58 pd=4.58 ps=4.58 nrd=0.145 nrs=0.145 sa=0 sb=0
+ sd=0 mult=1 m=1
XMDANT ND1 NDL VSS VSS sky130_fd_pr__nfet_g5v0d10v5 L=10 W=0.5 nf=1 ad=0.145 as=0.145 pd=1.58 ps=1.58 nrd=0.58 nrs=0.58 sa=0 sb=0
+ sd=0 mult=1 m=1
XMDBNI TRIP ND1 VSS VSS sky130_fd_pr__nfet_g5v0d10v5 L=1 W=1 nf=1 ad=0.29 as=0.29 pd=2.58 ps=2.58 nrd=0.29 nrs=0.29 sa=0 sb=0 sd=0
+ mult=1 m=1
XMDBPT TRIP PDN VDD VDD sky130_fd_pr__pfet_g5v0d10v5 L=10 W=0.5 nf=1 ad=0.145 as=0.145 pd=1.58 ps=1.58 nrd=0.58 nrs=0.58 sa=0 sb=0
+ sd=0 mult=1 m=1
XMRLK ND1 RESETn VSS VSS sky130_fd_pr__nfet_g5v0d10v5 L=1 W=1 nf=1 ad=0.29 as=0.29 pd=2.58 ps=2.58 nrd=0.29 nrs=0.29 sa=0 sb=0
+ sd=0 mult=1 m=1
XMNAP1 RSTB TRIP VDD VDD sky130_fd_pr__pfet_g5v0d10v5 L=0.5 W=4 nf=1 ad=1.16 as=1.16 pd=8.58 ps=8.58 nrd=0.0725 nrs=0.0725 sa=0
+ sb=0 sd=0 mult=1 m=1
XMNAP2 RSTB PGDG VDD VDD sky130_fd_pr__pfet_g5v0d10v5 L=0.5 W=4 nf=1 ad=1.16 as=1.16 pd=8.58 ps=8.58 nrd=0.0725 nrs=0.0725 sa=0
+ sb=0 sd=0 mult=1 m=1
XMNAN1 RSTB TRIP NNAND VSS sky130_fd_pr__nfet_g5v0d10v5 L=0.5 W=2 nf=1 ad=0.58 as=0.58 pd=4.58 ps=4.58 nrd=0.145 nrs=0.145 sa=0
+ sb=0 sd=0 mult=1 m=1
XMNAN2 NNAND PGDG VSS VSS sky130_fd_pr__nfet_g5v0d10v5 L=0.5 W=2 nf=1 ad=0.58 as=0.58 pd=4.58 ps=4.58 nrd=0.145 nrs=0.145 sa=0
+ sb=0 sd=0 mult=1 m=1
XMAST RSTB RESETn VDD VDD sky130_fd_pr__pfet_g5v0d10v5 L=10 W=0.5 nf=1 ad=0.145 as=0.145 pd=1.58 ps=1.58 nrd=0.58 nrs=0.58 sa=0
+ sb=0 sd=0 mult=1 m=1
XMOP RESETn RSTB VDD VDD sky130_fd_pr__pfet_g5v0d10v5 L=1 W=1 nf=1 ad=0.29 as=0.29 pd=2.58 ps=2.58 nrd=0.29 nrs=0.29 sa=0 sb=0
+ sd=0 mult=1 m=1
XMON RESETn RSTB VSS VSS sky130_fd_pr__nfet_g5v0d10v5 L=0.5 W=10 nf=1 ad=2.9 as=2.9 pd=20.58 ps=20.58 nrd=0.029 nrs=0.029 sa=0
+ sb=0 sd=0 mult=1 m=1
XMASSIST RESETn VDD VSS VSS sky130_fd_pr__nfet_05v0_nvt L=25 W=1 nf=1 ad=0.29 as=0.29 pd=2.58 ps=2.58 nrd=0.29 nrs=0.29 sa=0 sb=0
+ sd=0 mult=1 m=1
.ends
* bias_core -- generated by design/netlist.py from design/bias_core.sch
* Do not edit: edit the schematic and re-run the export.
** sch_path: design/bias_core.sch
.subckt bias_core VDD VSS IBIAS VREF BIAS_OK
*.PININFO VDD:B VSS:B IBIAS:O VREF:O BIAS_OK:O
XMP1 NA PG VDD VDD sky130_fd_pr__pfet_g5v0d10v5 L=4 W=8 nf=1 ad=2.32 as=2.32 pd=16.58 ps=16.58 nrd=0.03625 nrs=0.03625 sa=0 sb=0
+ sd=0 mult=1 m=1
XMP2 NBTOP PG VDD VDD sky130_fd_pr__pfet_g5v0d10v5 L=4 W=8 nf=1 ad=2.32 as=2.32 pd=16.58 ps=16.58 nrd=0.03625 nrs=0.03625 sa=0
+ sb=0 sd=0 mult=1 m=1
XMP3 VREF PG VDD VDD sky130_fd_pr__pfet_g5v0d10v5 L=4 W=8 nf=1 ad=2.32 as=2.32 pd=16.58 ps=16.58 nrd=0.03625 nrs=0.03625 sa=0 sb=0
+ sd=0 mult=1 m=1
XMPBN NBG PG VDD VDD sky130_fd_pr__pfet_g5v0d10v5 L=4 W=2 nf=1 ad=0.58 as=0.58 pd=4.58 ps=4.58 nrd=0.145 nrs=0.145 sa=0 sb=0 sd=0
+ mult=1 m=1
XQ1 VSS VSS NA sky130_fd_pr__pnp_05v5_W3p40L3p40 m=1 mult=1
XRT NBTOP NB VSS sky130_fd_pr__res_xhigh_po W=2 L=350.0 mult=1 m=1
XR1 NB EC VSS sky130_fd_pr__res_xhigh_po W=2 L=350.0 mult=1 m=1
XQ8A VSS VSS EC sky130_fd_pr__pnp_05v5_W3p40L3p40 m=1 mult=1
XQ8B VSS VSS EC sky130_fd_pr__pnp_05v5_W3p40L3p40 m=1 mult=1
XQ8C VSS VSS EC sky130_fd_pr__pnp_05v5_W3p40L3p40 m=1 mult=1
XQ8D VSS VSS EC sky130_fd_pr__pnp_05v5_W3p40L3p40 m=1 mult=1
XQ8E VSS VSS EC sky130_fd_pr__pnp_05v5_W3p40L3p40 m=1 mult=1
XQ8F VSS VSS EC sky130_fd_pr__pnp_05v5_W3p40L3p40 m=1 mult=1
XQ8G VSS VSS EC sky130_fd_pr__pnp_05v5_W3p40L3p40 m=1 mult=1
XQ8H VSS VSS EC sky130_fd_pr__pnp_05v5_W3p40L3p40 m=1 mult=1
XR2 VREF ER VSS sky130_fd_pr__res_xhigh_po W=2 L=4104.0 mult=1 m=1
XQR VSS VSS ER sky130_fd_pr__pnp_05v5_W3p40L3p40 m=1 mult=1
XMBN NBG NBG VSS VSS sky130_fd_pr__nfet_g5v0d10v5 L=4 W=2 nf=1 ad=0.58 as=0.58 pd=4.58 ps=4.58 nrd=0.145 nrs=0.145 sa=0 sb=0 sd=0
+ mult=1 m=1
XMBN2 PB NBG VSS VSS sky130_fd_pr__nfet_g5v0d10v5 L=4 W=2 nf=1 ad=0.58 as=0.58 pd=4.58 ps=4.58 nrd=0.145 nrs=0.145 sa=0 sb=0 sd=0
+ mult=1 m=1
XMBP PB PB VDD VDD sky130_fd_pr__pfet_g5v0d10v5 L=4 W=2 nf=1 ad=0.58 as=0.58 pd=4.58 ps=4.58 nrd=0.145 nrs=0.145 sa=0 sb=0 sd=0
+ mult=1 m=1
XMPIB IBIAS PB VDD VDD sky130_fd_pr__pfet_g5v0d10v5 L=4 W=40 nf=1 ad=11.6 as=11.6 pd=80.58 ps=80.58 nrd=0.00725 nrs=0.00725 sa=0
+ sb=0 sd=0 mult=1 m=1
XMPT NT PB VDD VDD sky130_fd_pr__pfet_g5v0d10v5 L=4 W=2 nf=1 ad=0.58 as=0.58 pd=4.58 ps=4.58 nrd=0.145 nrs=0.145 sa=0 sb=0 sd=0
+ mult=1 m=1
XMI1 N1 NA NT VDD sky130_fd_pr__pfet_g5v0d10v5 L=4 W=16 nf=1 ad=4.64 as=4.64 pd=32.58 ps=32.58 nrd=0.018125 nrs=0.018125 sa=0 sb=0
+ sd=0 mult=1 m=1
XMI2 N2 NB NT VDD sky130_fd_pr__pfet_g5v0d10v5 L=4 W=16 nf=1 ad=4.64 as=4.64 pd=32.58 ps=32.58 nrd=0.018125 nrs=0.018125 sa=0 sb=0
+ sd=0 mult=1 m=1
XML1 N1 N1 VSS VSS sky130_fd_pr__nfet_g5v0d10v5 L=8 W=4 nf=1 ad=1.16 as=1.16 pd=8.58 ps=8.58 nrd=0.0725 nrs=0.0725 sa=0 sb=0 sd=0
+ mult=1 m=1
XML2 N2 N1 VSS VSS sky130_fd_pr__nfet_g5v0d10v5 L=8 W=4 nf=1 ad=1.16 as=1.16 pd=8.58 ps=8.58 nrd=0.0725 nrs=0.0725 sa=0 sb=0 sd=0
+ mult=1 m=1
XMS2N PG N2 VSS VSS sky130_fd_pr__nfet_g5v0d10v5 L=8 W=8 nf=1 ad=2.32 as=2.32 pd=16.58 ps=16.58 nrd=0.03625 nrs=0.03625 sa=0 sb=0
+ sd=0 mult=1 m=1
XMS2P PG PB VDD VDD sky130_fd_pr__pfet_g5v0d10v5 L=4 W=2 nf=1 ad=0.58 as=0.58 pd=4.58 ps=4.58 nrd=0.145 nrs=0.145 sa=0 sb=0 sd=0
+ mult=1 m=1
XCC PG NZ sky130_fd_pr__cap_mim_m3_1 W=20 L=20 MF=1 m=1
XRZ NZ N2 VSS sky130_fd_pr__res_xhigh_po W=2 L=1016.0 mult=1 m=1
XKS0 VDD VDD KS1 VSS sky130_fd_pr__nfet_g5v0d10v5 L=8 W=1 nf=1 ad=0.29 as=0.29 pd=2.58 ps=2.58 nrd=0.29 nrs=0.29 sa=0 sb=0 sd=0
+ mult=1 m=1
XKS1 KS1 KS1 KS2 VSS sky130_fd_pr__nfet_g5v0d10v5 L=8 W=1 nf=1 ad=0.29 as=0.29 pd=2.58 ps=2.58 nrd=0.29 nrs=0.29 sa=0 sb=0 sd=0
+ mult=1 m=1
XKS2 KS2 KS2 KS3 VSS sky130_fd_pr__nfet_g5v0d10v5 L=8 W=1 nf=1 ad=0.29 as=0.29 pd=2.58 ps=2.58 nrd=0.29 nrs=0.29 sa=0 sb=0 sd=0
+ mult=1 m=1
XKS3 KS3 KS3 KS4 VSS sky130_fd_pr__nfet_g5v0d10v5 L=8 W=1 nf=1 ad=0.29 as=0.29 pd=2.58 ps=2.58 nrd=0.29 nrs=0.29 sa=0 sb=0 sd=0
+ mult=1 m=1
XKS4 KS4 KS4 NKG VSS sky130_fd_pr__nfet_g5v0d10v5 L=8 W=1 nf=1 ad=0.29 as=0.29 pd=2.58 ps=2.58 nrd=0.29 nrs=0.29 sa=0 sb=0 sd=0
+ mult=1 m=1
XKA NKM PB VDD VDD sky130_fd_pr__pfet_g5v0d10v5 L=4 W=1 nf=1 ad=0.29 as=0.29 pd=2.58 ps=2.58 nrd=0.29 nrs=0.29 sa=0 sb=0 sd=0
+ mult=1 m=1
XKAN NKM NKM VSS VSS sky130_fd_pr__nfet_g5v0d10v5 L=4 W=2 nf=1 ad=0.58 as=0.58 pd=4.58 ps=4.58 nrd=0.145 nrs=0.145 sa=0 sb=0 sd=0
+ mult=1 m=1
XKPD NKG NKM VSS VSS sky130_fd_pr__nfet_g5v0d10v5 L=4 W=8 nf=1 ad=2.32 as=2.32 pd=16.58 ps=16.58 nrd=0.03625 nrs=0.03625 sa=0 sb=0
+ sd=0 mult=1 m=1
XKICK PG NKG VSS VSS sky130_fd_pr__nfet_g5v0d10v5 L=4 W=1 nf=1 ad=0.29 as=0.29 pd=2.58 ps=2.58 nrd=0.29 nrs=0.29 sa=0 sb=0 sd=0
+ mult=1 m=1
XMPOK TOK PB VDD VDD sky130_fd_pr__pfet_g5v0d10v5 L=4 W=1 nf=1 ad=0.29 as=0.29 pd=2.58 ps=2.58 nrd=0.29 nrs=0.29 sa=0 sb=0 sd=0
+ mult=1 m=1
XMOKA NOKO NA TOK VDD sky130_fd_pr__pfet_g5v0d10v5 L=8 W=16 nf=1 ad=4.64 as=4.64 pd=32.58 ps=32.58 nrd=0.018125 nrs=0.018125 sa=0
+ sb=0 sd=0 mult=1 m=1
XMOKB NOKL NBTOP TOK VDD sky130_fd_pr__pfet_g5v0d10v5 L=8 W=16 nf=1 ad=4.64 as=4.64 pd=32.58 ps=32.58 nrd=0.018125 nrs=0.018125
+ sa=0 sb=0 sd=0 mult=1 m=1
XMOL1 NOKL NOKL VSS VSS sky130_fd_pr__nfet_g5v0d10v5 L=16 W=4 nf=1 ad=1.16 as=1.16 pd=8.58 ps=8.58 nrd=0.0725 nrs=0.0725 sa=0 sb=0
+ sd=0 mult=1 m=1
VOFF NOKLG NOKL DC {voff}
XMOL2 NOKO NOKLG VSS VSS sky130_fd_pr__nfet_g5v0d10v5 L=16 W=4 nf=1 ad=1.16 as=1.16 pd=8.58 ps=8.58 nrd=0.0725 nrs=0.0725 sa=0 sb=0
+ sd=0 mult=1 m=1
XMOKC NOKO NKG VSS VSS sky130_fd_pr__nfet_g5v0d10v5 L=1 W=2 nf=1 ad=0.58 as=0.58 pd=4.58 ps=4.58 nrd=0.145 nrs=0.145 sa=0 sb=0
+ sd=0 mult=1 m=1
XMOK2 NOKX NOKO VSS VSS sky130_fd_pr__nfet_g5v0d10v5 L=4 W=8 nf=1 ad=2.32 as=2.32 pd=16.58 ps=16.58 nrd=0.03625 nrs=0.03625 sa=0
+ sb=0 sd=0 mult=1 m=1
XMOK2P NOKX PB VDD VDD sky130_fd_pr__pfet_g5v0d10v5 L=4 W=0.5 nf=1 ad=0.145 as=0.145 pd=1.58 ps=1.58 nrd=0.58 nrs=0.58 sa=0 sb=0
+ sd=0 mult=1 m=1
XCOK VDD NOKX sky130_fd_pr__cap_mim_m3_1 W=6 L=6 MF=1 m=1
XMO1P BIAS_OK NOKX VDD VDD sky130_fd_pr__pfet_g5v0d10v5 L=4 W=1 nf=1 ad=0.29 as=0.29 pd=2.58 ps=2.58 nrd=0.29 nrs=0.29 sa=0 sb=0
+ sd=0 mult=1 m=1
XMO1N BIAS_OK NOKX VSS VSS sky130_fd_pr__nfet_g5v0d10v5 L=0.5 W=4 nf=1 ad=1.16 as=1.16 pd=8.58 ps=8.58 nrd=0.0725 nrs=0.0725 sa=0
+ sb=0 sd=0 mult=1 m=1
XMOKH NOKX BIAS_OK VDD VDD sky130_fd_pr__pfet_g5v0d10v5 L=4 W=2 nf=1 ad=0.58 as=0.58 pd=4.58 ps=4.58 nrd=0.145 nrs=0.145 sa=0 sb=0
+ sd=0 mult=1 m=1
.ends

* ===== derived netlist, offset device XMOKA =====
** klt-netlist-inputs: {"pdk_variant": "sky130A", "rcfile": "xschemrc", "xschem_version": "3.4.7"}
** sch_path: sim/por-bias-ok-early-assert/testbench/tb_bias_ok_early_assert.sch
**.subckt tb_bias_ok_early_assert
VSET VSETN 0 3.63
BVDD VDD 0 V = min(v(VSETN), min({rate}*time, max(0, 2*v(VSETN) - {rate}*time))) m=1
XDUT VDD 0 IBIAS VREF BIAS_OK POR_RAW por_comparator
XCHAIN VDD 0 IBIAS POR_RAW RESETn por_output_chain
XBIAS VDD 0 IBIAS VREF BIAS_OK bias_core
**** begin user architecture code

.save v(vdd) v(por_raw) v(resetn) v(vref) v(ibias) v(bias_ok) i(bvdd)
.save v(xdut.sns) v(xdut.snsb) v(xdut.n1) v(xdut.cmpo)
* issue #455: OK-detector internal nodes of the real bias_core, so a failed-release
* realisation can be attributed inside the settle detector (input pair / mirror / output
* stage) from per-sample node levels, not only from BIAS_OK itself
.save v(xbias.na) v(xbias.nbtop) v(xbias.pb) v(xbias.tok) v(xbias.noko) v(xbias.nokl) v(xbias.nokx) v(xbias.nkg)
.options method=gear trtol=50

**** end user architecture code
**.ends

* por_comparator -- generated by design/netlist.py from design/por_comparator.sch
* Do not edit: edit the schematic and re-run the export.
** sch_path: design/por_comparator.sch
.subckt por_comparator VDD VSS IBIAS VREF BIAS_OK POR_RAW
*.PININFO VDD:B VSS:B IBIAS:I VREF:I BIAS_OK:I POR_RAW:O
XMENP BIAS_OKB BIAS_OK VDD VDD sky130_fd_pr__pfet_g5v0d10v5 L=0.5 W=2 nf=1 ad=0.58 as=0.58 pd=4.58 ps=4.58 nrd=0.145 nrs=0.145
+ sa=0 sb=0 sd=0 mult=1 m=1
XMENN BIAS_OKB BIAS_OK VSS VSS sky130_fd_pr__nfet_g5v0d10v5 L=0.5 W=1 nf=1 ad=0.29 as=0.29 pd=2.58 ps=2.58 nrd=0.29 nrs=0.29 sa=0
+ sb=0 sd=0 mult=1 m=1
XMBD IBIAS NBG VSS VSS sky130_fd_pr__nfet_g5v0d10v5 L=2 W=2 nf=1 ad=0.58 as=0.58 pd=4.58 ps=4.58 nrd=0.145 nrs=0.145 sa=0 sb=0
+ sd=0 mult=1 m=1
XMPASS IBIAS BIAS_OK NBG VSS sky130_fd_pr__nfet_g5v0d10v5 L=0.5 W=2 nf=1 ad=0.58 as=0.58 pd=4.58 ps=4.58 nrd=0.145 nrs=0.145 sa=0
+ sb=0 sd=0 mult=1 m=1
XMDNB NBG BIAS_OKB VSS VSS sky130_fd_pr__nfet_g5v0d10v5 L=0.5 W=2 nf=1 ad=0.58 as=0.58 pd=4.58 ps=4.58 nrd=0.145 nrs=0.145 sa=0
+ sb=0 sd=0 mult=1 m=1
XMDIB IBIAS BIAS_OKB VSS VSS sky130_fd_pr__nfet_g5v0d10v5 L=1 W=1 nf=1 ad=0.29 as=0.29 pd=2.58 ps=2.58 nrd=0.29 nrs=0.29 sa=0 sb=0
+ sd=0 mult=1 m=1
XRTOP SNS VDD VSS sky130_fd_pr__res_xhigh_po W=2 L=7897.44 mult=1 m=1
XRBOT SNSB SNS VSS sky130_fd_pr__res_xhigh_po W=2 L=6769.23 mult=1 m=1
XRHYS VSS SNSB VSS sky130_fd_pr__res_xhigh_po W=2 L=775.0 mult=1 m=1
XMHSW SNSB N1 VSS VSS sky130_fd_pr__nfet_g5v0d10v5 L=0.5 W=10 nf=1 ad=2.9 as=2.9 pd=20.58 ps=20.58 nrd=0.029 nrs=0.029 sa=0 sb=0
+ sd=0 mult=1 m=1
XMTAIL TN NBG VSS VSS sky130_fd_pr__nfet_g5v0d10v5 L=10 W=1 nf=1 ad=0.29 as=0.29 pd=2.58 ps=2.58 nrd=0.29 nrs=0.29 sa=0 sb=0 sd=0
+ mult=1 m=1
XMINA NA SNS TN VSS sky130_fd_pr__nfet_g5v0d10v5 L=1 W=2 nf=1 ad=0.58 as=0.58 pd=4.58 ps=4.58 nrd=0.145 nrs=0.145 sa=0 sb=0 sd=0
+ mult=1 m=1
XMINB CMPO VREF TN VSS sky130_fd_pr__nfet_g5v0d10v5 L=1 W=2 nf=1 ad=0.58 as=0.58 pd=4.58 ps=4.58 nrd=0.145 nrs=0.145 sa=0 sb=0
+ sd=0 mult=1 m=1
XMLA NA NA VDDA VDD sky130_fd_pr__pfet_g5v0d10v5 L=1 W=4 nf=1 ad=1.16 as=1.16 pd=8.58 ps=8.58 nrd=0.0725 nrs=0.0725 sa=0 sb=0 sd=0
+ mult=1 m=1
XMLB CMPO NA VDDA VDD sky130_fd_pr__pfet_g5v0d10v5 L=1 W=4 nf=1 ad=1.16 as=1.16 pd=8.58 ps=8.58 nrd=0.0725 nrs=0.0725 sa=0 sb=0
+ sd=0 mult=1 m=1
XMENSRC VDDA BIAS_OKB VDD VDD sky130_fd_pr__pfet_g5v0d10v5 L=0.5 W=4 nf=1 ad=1.16 as=1.16 pd=8.58 ps=8.58 nrd=0.0725 nrs=0.0725
+ sa=0 sb=0 sd=0 mult=1 m=1
XMDCMPO CMPO BIAS_OKB VSS VSS sky130_fd_pr__nfet_g5v0d10v5 L=1 W=2 nf=1 ad=0.58 as=0.58 pd=4.58 ps=4.58 nrd=0.145 nrs=0.145 sa=0
+ sb=0 sd=0 mult=1 m=1
XMI1P N1 CMPO VDD VDD sky130_fd_pr__pfet_g5v0d10v5 L=0.5 W=2 nf=1 ad=0.58 as=0.58 pd=4.58 ps=4.58 nrd=0.145 nrs=0.145 sa=0 sb=0
+ sd=0 mult=1 m=1
XMI1N N1 CMPO VSS VSS sky130_fd_pr__nfet_g5v0d10v5 L=0.5 W=1 nf=1 ad=0.29 as=0.29 pd=2.58 ps=2.58 nrd=0.29 nrs=0.29 sa=0 sb=0 sd=0
+ mult=1 m=1
XMI2P POR_RAW N1 VDD VDD sky130_fd_pr__pfet_g5v0d10v5 L=0.5 W=2 nf=1 ad=0.58 as=0.58 pd=4.58 ps=4.58 nrd=0.145 nrs=0.145 sa=0 sb=0
+ sd=0 mult=1 m=1
XMI2N POR_RAW N1 VSS VSS sky130_fd_pr__nfet_g5v0d10v5 L=0.5 W=1 nf=1 ad=0.29 as=0.29 pd=2.58 ps=2.58 nrd=0.29 nrs=0.29 sa=0 sb=0
+ sd=0 mult=1 m=1
.ends
* por_output_chain -- generated by design/netlist.py from design/por_output_chain.sch
* Do not edit: edit the schematic and re-run the export.
** sch_path: design/por_output_chain.sch
.subckt por_output_chain VDD VSS IBIAS POR_RAW RESETn
*.PININFO VDD:B VSS:B IBIAS:I POR_RAW:I RESETn:O
XMBD IBIAS IBIAS VSS VSS sky130_fd_pr__nfet_g5v0d10v5 L=4 W=4 nf=1 ad=1.16 as=1.16 pd=8.58 ps=8.58 nrd=0.0725 nrs=0.0725 sa=0 sb=0
+ sd=0 mult=1 m=1
XMN1 PDN IBIAS VSS VSS sky130_fd_pr__nfet_g5v0d10v5 L=20 W=0.42 nf=1 ad=0.1218 as=0.1218 pd=1.42 ps=1.42 nrd=0.69047619047619
+ nrs=0.69047619047619 sa=0 sb=0 sd=0 mult=1 m=1
XMPD PDN PDN VDD VDD sky130_fd_pr__pfet_g5v0d10v5 L=10 W=2 nf=1 ad=0.58 as=0.58 pd=4.58 ps=4.58 nrd=0.145 nrs=0.145 sa=0 sb=0 sd=0
+ mult=1 m=1
XMP2 NDL PDN VDD VDD sky130_fd_pr__pfet_g5v0d10v5 L=10 W=2 nf=1 ad=0.58 as=0.58 pd=4.58 ps=4.58 nrd=0.145 nrs=0.145 sa=0 sb=0 sd=0
+ mult=1 m=1
XMND NDL NDL VSS VSS sky130_fd_pr__nfet_g5v0d10v5 L=10 W=2 nf=1 ad=0.58 as=0.58 pd=4.58 ps=4.58 nrd=0.145 nrs=0.145 sa=0 sb=0 sd=0
+ mult=1 m=1
XMDGPT NDGP PDN VDD VDD sky130_fd_pr__pfet_g5v0d10v5 L=10 W=10 nf=1 ad=2.9 as=2.9 pd=20.58 ps=20.58 nrd=0.029 nrs=0.029 sa=0 sb=0
+ sd=0 mult=1 m=1
XMDGPI NDG POR_RAW NDGP VDD sky130_fd_pr__pfet_g5v0d10v5 L=0.5 W=1 nf=1 ad=0.29 as=0.29 pd=2.58 ps=2.58 nrd=0.29 nrs=0.29 sa=0
+ sb=0 sd=0 mult=1 m=1
XMDGNI NDG POR_RAW NDGN VSS sky130_fd_pr__nfet_g5v0d10v5 L=0.5 W=1 nf=1 ad=0.29 as=0.29 pd=2.58 ps=2.58 nrd=0.29 nrs=0.29 sa=0
+ sb=0 sd=0 mult=1 m=1
XMDGNT NDGN NDL VSS VSS sky130_fd_pr__nfet_g5v0d10v5 L=10 W=10 nf=1 ad=2.9 as=2.9 pd=20.58 ps=20.58 nrd=0.029 nrs=0.029 sa=0 sb=0
+ sd=0 mult=1 m=1
XCDG NDG VSS sky130_fd_pr__cap_mim_m3_1 W=11 L=11 MF=1 m=1
XMG1P PGDG NDG VDD VDD sky130_fd_pr__pfet_g5v0d10v5 L=2 W=0.5 nf=1 ad=0.145 as=0.145 pd=1.58 ps=1.58 nrd=0.58 nrs=0.58 sa=0 sb=0
+ sd=0 mult=1 m=1
XMG1N PGDG NDG VSS VSS sky130_fd_pr__nfet_g5v0d10v5 L=0.5 W=2 nf=1 ad=0.58 as=0.58 pd=4.58 ps=4.58 nrd=0.145 nrs=0.145 sa=0 sb=0
+ sd=0 mult=1 m=1
XMG2P PGDGB PGDG VDD VDD sky130_fd_pr__pfet_g5v0d10v5 L=0.5 W=2 nf=1 ad=0.58 as=0.58 pd=4.58 ps=4.58 nrd=0.145 nrs=0.145 sa=0 sb=0
+ sd=0 mult=1 m=1
XMG2N PGDGB PGDG VSS VSS sky130_fd_pr__nfet_g5v0d10v5 L=2 W=0.5 nf=1 ad=0.145 as=0.145 pd=1.58 ps=1.58 nrd=0.58 nrs=0.58 sa=0 sb=0
+ sd=0 mult=1 m=1
XMPT NTS PDN VDD VDD sky130_fd_pr__pfet_g5v0d10v5 L=10 W=0.5 nf=1 ad=0.145 as=0.145 pd=1.58 ps=1.58 nrd=0.58 nrs=0.58 sa=0 sb=0
+ sd=0 mult=1 m=1
XMTSW TIM PGDGB NTS VDD sky130_fd_pr__pfet_g5v0d10v5 L=1 W=2 nf=1 ad=0.58 as=0.58 pd=4.58 ps=4.58 nrd=0.145 nrs=0.145 sa=0 sb=0
+ sd=0 mult=1 m=1
XMDIS TIM PGDGB VSS VSS sky130_fd_pr__nfet_g5v0d10v5 L=1 W=1 nf=1 ad=0.29 as=0.29 pd=2.58 ps=2.58 nrd=0.29 nrs=0.29 sa=0 sb=0 sd=0
+ mult=1 m=1
XCTIM TIM VSS sky130_fd_pr__cap_mim_m3_1 W=28 L=28 MF=4 m=4
XMDAPI ND1 TIM VDD VDD sky130_fd_pr__pfet_g5v0d10v5 L=1 W=2 nf=1 ad=0.58 as=0.58 pd=4.58 ps=4.58 nrd=0.145 nrs=0.145 sa=0 sb=0
+ sd=0 mult=1 m=1
XMDANT ND1 NDL VSS VSS sky130_fd_pr__nfet_g5v0d10v5 L=10 W=0.5 nf=1 ad=0.145 as=0.145 pd=1.58 ps=1.58 nrd=0.58 nrs=0.58 sa=0 sb=0
+ sd=0 mult=1 m=1
XMDBNI TRIP ND1 VSS VSS sky130_fd_pr__nfet_g5v0d10v5 L=1 W=1 nf=1 ad=0.29 as=0.29 pd=2.58 ps=2.58 nrd=0.29 nrs=0.29 sa=0 sb=0 sd=0
+ mult=1 m=1
XMDBPT TRIP PDN VDD VDD sky130_fd_pr__pfet_g5v0d10v5 L=10 W=0.5 nf=1 ad=0.145 as=0.145 pd=1.58 ps=1.58 nrd=0.58 nrs=0.58 sa=0 sb=0
+ sd=0 mult=1 m=1
XMRLK ND1 RESETn VSS VSS sky130_fd_pr__nfet_g5v0d10v5 L=1 W=1 nf=1 ad=0.29 as=0.29 pd=2.58 ps=2.58 nrd=0.29 nrs=0.29 sa=0 sb=0
+ sd=0 mult=1 m=1
XMNAP1 RSTB TRIP VDD VDD sky130_fd_pr__pfet_g5v0d10v5 L=0.5 W=4 nf=1 ad=1.16 as=1.16 pd=8.58 ps=8.58 nrd=0.0725 nrs=0.0725 sa=0
+ sb=0 sd=0 mult=1 m=1
XMNAP2 RSTB PGDG VDD VDD sky130_fd_pr__pfet_g5v0d10v5 L=0.5 W=4 nf=1 ad=1.16 as=1.16 pd=8.58 ps=8.58 nrd=0.0725 nrs=0.0725 sa=0
+ sb=0 sd=0 mult=1 m=1
XMNAN1 RSTB TRIP NNAND VSS sky130_fd_pr__nfet_g5v0d10v5 L=0.5 W=2 nf=1 ad=0.58 as=0.58 pd=4.58 ps=4.58 nrd=0.145 nrs=0.145 sa=0
+ sb=0 sd=0 mult=1 m=1
XMNAN2 NNAND PGDG VSS VSS sky130_fd_pr__nfet_g5v0d10v5 L=0.5 W=2 nf=1 ad=0.58 as=0.58 pd=4.58 ps=4.58 nrd=0.145 nrs=0.145 sa=0
+ sb=0 sd=0 mult=1 m=1
XMAST RSTB RESETn VDD VDD sky130_fd_pr__pfet_g5v0d10v5 L=10 W=0.5 nf=1 ad=0.145 as=0.145 pd=1.58 ps=1.58 nrd=0.58 nrs=0.58 sa=0
+ sb=0 sd=0 mult=1 m=1
XMOP RESETn RSTB VDD VDD sky130_fd_pr__pfet_g5v0d10v5 L=1 W=1 nf=1 ad=0.29 as=0.29 pd=2.58 ps=2.58 nrd=0.29 nrs=0.29 sa=0 sb=0
+ sd=0 mult=1 m=1
XMON RESETn RSTB VSS VSS sky130_fd_pr__nfet_g5v0d10v5 L=0.5 W=10 nf=1 ad=2.9 as=2.9 pd=20.58 ps=20.58 nrd=0.029 nrs=0.029 sa=0
+ sb=0 sd=0 mult=1 m=1
XMASSIST RESETn VDD VSS VSS sky130_fd_pr__nfet_05v0_nvt L=25 W=1 nf=1 ad=0.29 as=0.29 pd=2.58 ps=2.58 nrd=0.29 nrs=0.29 sa=0 sb=0
+ sd=0 mult=1 m=1
.ends
* bias_core -- generated by design/netlist.py from design/bias_core.sch
* Do not edit: edit the schematic and re-run the export.
** sch_path: design/bias_core.sch
.subckt bias_core VDD VSS IBIAS VREF BIAS_OK
*.PININFO VDD:B VSS:B IBIAS:O VREF:O BIAS_OK:O
XMP1 NA PG VDD VDD sky130_fd_pr__pfet_g5v0d10v5 L=4 W=8 nf=1 ad=2.32 as=2.32 pd=16.58 ps=16.58 nrd=0.03625 nrs=0.03625 sa=0 sb=0
+ sd=0 mult=1 m=1
XMP2 NBTOP PG VDD VDD sky130_fd_pr__pfet_g5v0d10v5 L=4 W=8 nf=1 ad=2.32 as=2.32 pd=16.58 ps=16.58 nrd=0.03625 nrs=0.03625 sa=0
+ sb=0 sd=0 mult=1 m=1
XMP3 VREF PG VDD VDD sky130_fd_pr__pfet_g5v0d10v5 L=4 W=8 nf=1 ad=2.32 as=2.32 pd=16.58 ps=16.58 nrd=0.03625 nrs=0.03625 sa=0 sb=0
+ sd=0 mult=1 m=1
XMPBN NBG PG VDD VDD sky130_fd_pr__pfet_g5v0d10v5 L=4 W=2 nf=1 ad=0.58 as=0.58 pd=4.58 ps=4.58 nrd=0.145 nrs=0.145 sa=0 sb=0 sd=0
+ mult=1 m=1
XQ1 VSS VSS NA sky130_fd_pr__pnp_05v5_W3p40L3p40 m=1 mult=1
XRT NBTOP NB VSS sky130_fd_pr__res_xhigh_po W=2 L=350.0 mult=1 m=1
XR1 NB EC VSS sky130_fd_pr__res_xhigh_po W=2 L=350.0 mult=1 m=1
XQ8A VSS VSS EC sky130_fd_pr__pnp_05v5_W3p40L3p40 m=1 mult=1
XQ8B VSS VSS EC sky130_fd_pr__pnp_05v5_W3p40L3p40 m=1 mult=1
XQ8C VSS VSS EC sky130_fd_pr__pnp_05v5_W3p40L3p40 m=1 mult=1
XQ8D VSS VSS EC sky130_fd_pr__pnp_05v5_W3p40L3p40 m=1 mult=1
XQ8E VSS VSS EC sky130_fd_pr__pnp_05v5_W3p40L3p40 m=1 mult=1
XQ8F VSS VSS EC sky130_fd_pr__pnp_05v5_W3p40L3p40 m=1 mult=1
XQ8G VSS VSS EC sky130_fd_pr__pnp_05v5_W3p40L3p40 m=1 mult=1
XQ8H VSS VSS EC sky130_fd_pr__pnp_05v5_W3p40L3p40 m=1 mult=1
XR2 VREF ER VSS sky130_fd_pr__res_xhigh_po W=2 L=4104.0 mult=1 m=1
XQR VSS VSS ER sky130_fd_pr__pnp_05v5_W3p40L3p40 m=1 mult=1
XMBN NBG NBG VSS VSS sky130_fd_pr__nfet_g5v0d10v5 L=4 W=2 nf=1 ad=0.58 as=0.58 pd=4.58 ps=4.58 nrd=0.145 nrs=0.145 sa=0 sb=0 sd=0
+ mult=1 m=1
XMBN2 PB NBG VSS VSS sky130_fd_pr__nfet_g5v0d10v5 L=4 W=2 nf=1 ad=0.58 as=0.58 pd=4.58 ps=4.58 nrd=0.145 nrs=0.145 sa=0 sb=0 sd=0
+ mult=1 m=1
XMBP PB PB VDD VDD sky130_fd_pr__pfet_g5v0d10v5 L=4 W=2 nf=1 ad=0.58 as=0.58 pd=4.58 ps=4.58 nrd=0.145 nrs=0.145 sa=0 sb=0 sd=0
+ mult=1 m=1
XMPIB IBIAS PB VDD VDD sky130_fd_pr__pfet_g5v0d10v5 L=4 W=40 nf=1 ad=11.6 as=11.6 pd=80.58 ps=80.58 nrd=0.00725 nrs=0.00725 sa=0
+ sb=0 sd=0 mult=1 m=1
XMPT NT PB VDD VDD sky130_fd_pr__pfet_g5v0d10v5 L=4 W=2 nf=1 ad=0.58 as=0.58 pd=4.58 ps=4.58 nrd=0.145 nrs=0.145 sa=0 sb=0 sd=0
+ mult=1 m=1
XMI1 N1 NA NT VDD sky130_fd_pr__pfet_g5v0d10v5 L=4 W=16 nf=1 ad=4.64 as=4.64 pd=32.58 ps=32.58 nrd=0.018125 nrs=0.018125 sa=0 sb=0
+ sd=0 mult=1 m=1
XMI2 N2 NB NT VDD sky130_fd_pr__pfet_g5v0d10v5 L=4 W=16 nf=1 ad=4.64 as=4.64 pd=32.58 ps=32.58 nrd=0.018125 nrs=0.018125 sa=0 sb=0
+ sd=0 mult=1 m=1
XML1 N1 N1 VSS VSS sky130_fd_pr__nfet_g5v0d10v5 L=8 W=4 nf=1 ad=1.16 as=1.16 pd=8.58 ps=8.58 nrd=0.0725 nrs=0.0725 sa=0 sb=0 sd=0
+ mult=1 m=1
XML2 N2 N1 VSS VSS sky130_fd_pr__nfet_g5v0d10v5 L=8 W=4 nf=1 ad=1.16 as=1.16 pd=8.58 ps=8.58 nrd=0.0725 nrs=0.0725 sa=0 sb=0 sd=0
+ mult=1 m=1
XMS2N PG N2 VSS VSS sky130_fd_pr__nfet_g5v0d10v5 L=8 W=8 nf=1 ad=2.32 as=2.32 pd=16.58 ps=16.58 nrd=0.03625 nrs=0.03625 sa=0 sb=0
+ sd=0 mult=1 m=1
XMS2P PG PB VDD VDD sky130_fd_pr__pfet_g5v0d10v5 L=4 W=2 nf=1 ad=0.58 as=0.58 pd=4.58 ps=4.58 nrd=0.145 nrs=0.145 sa=0 sb=0 sd=0
+ mult=1 m=1
XCC PG NZ sky130_fd_pr__cap_mim_m3_1 W=20 L=20 MF=1 m=1
XRZ NZ N2 VSS sky130_fd_pr__res_xhigh_po W=2 L=1016.0 mult=1 m=1
XKS0 VDD VDD KS1 VSS sky130_fd_pr__nfet_g5v0d10v5 L=8 W=1 nf=1 ad=0.29 as=0.29 pd=2.58 ps=2.58 nrd=0.29 nrs=0.29 sa=0 sb=0 sd=0
+ mult=1 m=1
XKS1 KS1 KS1 KS2 VSS sky130_fd_pr__nfet_g5v0d10v5 L=8 W=1 nf=1 ad=0.29 as=0.29 pd=2.58 ps=2.58 nrd=0.29 nrs=0.29 sa=0 sb=0 sd=0
+ mult=1 m=1
XKS2 KS2 KS2 KS3 VSS sky130_fd_pr__nfet_g5v0d10v5 L=8 W=1 nf=1 ad=0.29 as=0.29 pd=2.58 ps=2.58 nrd=0.29 nrs=0.29 sa=0 sb=0 sd=0
+ mult=1 m=1
XKS3 KS3 KS3 KS4 VSS sky130_fd_pr__nfet_g5v0d10v5 L=8 W=1 nf=1 ad=0.29 as=0.29 pd=2.58 ps=2.58 nrd=0.29 nrs=0.29 sa=0 sb=0 sd=0
+ mult=1 m=1
XKS4 KS4 KS4 NKG VSS sky130_fd_pr__nfet_g5v0d10v5 L=8 W=1 nf=1 ad=0.29 as=0.29 pd=2.58 ps=2.58 nrd=0.29 nrs=0.29 sa=0 sb=0 sd=0
+ mult=1 m=1
XKA NKM PB VDD VDD sky130_fd_pr__pfet_g5v0d10v5 L=4 W=1 nf=1 ad=0.29 as=0.29 pd=2.58 ps=2.58 nrd=0.29 nrs=0.29 sa=0 sb=0 sd=0
+ mult=1 m=1
XKAN NKM NKM VSS VSS sky130_fd_pr__nfet_g5v0d10v5 L=4 W=2 nf=1 ad=0.58 as=0.58 pd=4.58 ps=4.58 nrd=0.145 nrs=0.145 sa=0 sb=0 sd=0
+ mult=1 m=1
XKPD NKG NKM VSS VSS sky130_fd_pr__nfet_g5v0d10v5 L=4 W=8 nf=1 ad=2.32 as=2.32 pd=16.58 ps=16.58 nrd=0.03625 nrs=0.03625 sa=0 sb=0
+ sd=0 mult=1 m=1
XKICK PG NKG VSS VSS sky130_fd_pr__nfet_g5v0d10v5 L=4 W=1 nf=1 ad=0.29 as=0.29 pd=2.58 ps=2.58 nrd=0.29 nrs=0.29 sa=0 sb=0 sd=0
+ mult=1 m=1
XMPOK TOK PB VDD VDD sky130_fd_pr__pfet_g5v0d10v5 L=4 W=1 nf=1 ad=0.29 as=0.29 pd=2.58 ps=2.58 nrd=0.29 nrs=0.29 sa=0 sb=0 sd=0
+ mult=1 m=1
VOFF NAG NA DC {voff}
XMOKA NOKO NAG TOK VDD sky130_fd_pr__pfet_g5v0d10v5 L=8 W=16 nf=1 ad=4.64 as=4.64 pd=32.58 ps=32.58 nrd=0.018125 nrs=0.018125 sa=0
+ sb=0 sd=0 mult=1 m=1
XMOKB NOKL NBTOP TOK VDD sky130_fd_pr__pfet_g5v0d10v5 L=8 W=16 nf=1 ad=4.64 as=4.64 pd=32.58 ps=32.58 nrd=0.018125 nrs=0.018125
+ sa=0 sb=0 sd=0 mult=1 m=1
XMOL1 NOKL NOKL VSS VSS sky130_fd_pr__nfet_g5v0d10v5 L=16 W=4 nf=1 ad=1.16 as=1.16 pd=8.58 ps=8.58 nrd=0.0725 nrs=0.0725 sa=0 sb=0
+ sd=0 mult=1 m=1
XMOL2 NOKO NOKL VSS VSS sky130_fd_pr__nfet_g5v0d10v5 L=16 W=4 nf=1 ad=1.16 as=1.16 pd=8.58 ps=8.58 nrd=0.0725 nrs=0.0725 sa=0 sb=0
+ sd=0 mult=1 m=1
XMOKC NOKO NKG VSS VSS sky130_fd_pr__nfet_g5v0d10v5 L=1 W=2 nf=1 ad=0.58 as=0.58 pd=4.58 ps=4.58 nrd=0.145 nrs=0.145 sa=0 sb=0
+ sd=0 mult=1 m=1
XMOK2 NOKX NOKO VSS VSS sky130_fd_pr__nfet_g5v0d10v5 L=4 W=8 nf=1 ad=2.32 as=2.32 pd=16.58 ps=16.58 nrd=0.03625 nrs=0.03625 sa=0
+ sb=0 sd=0 mult=1 m=1
XMOK2P NOKX PB VDD VDD sky130_fd_pr__pfet_g5v0d10v5 L=4 W=0.5 nf=1 ad=0.145 as=0.145 pd=1.58 ps=1.58 nrd=0.58 nrs=0.58 sa=0 sb=0
+ sd=0 mult=1 m=1
XCOK VDD NOKX sky130_fd_pr__cap_mim_m3_1 W=6 L=6 MF=1 m=1
XMO1P BIAS_OK NOKX VDD VDD sky130_fd_pr__pfet_g5v0d10v5 L=4 W=1 nf=1 ad=0.29 as=0.29 pd=2.58 ps=2.58 nrd=0.29 nrs=0.29 sa=0 sb=0
+ sd=0 mult=1 m=1
XMO1N BIAS_OK NOKX VSS VSS sky130_fd_pr__nfet_g5v0d10v5 L=0.5 W=4 nf=1 ad=1.16 as=1.16 pd=8.58 ps=8.58 nrd=0.0725 nrs=0.0725 sa=0
+ sb=0 sd=0 mult=1 m=1
XMOKH NOKX BIAS_OK VDD VDD sky130_fd_pr__pfet_g5v0d10v5 L=4 W=2 nf=1 ad=0.58 as=0.58 pd=4.58 ps=4.58 nrd=0.145 nrs=0.145 sa=0 sb=0
+ sd=0 mult=1 m=1
.ends

.end
